.title KiCad schematic
.include "/home/user/dlnn/hw/board/lib/dlnn_sim.lib"
RVA1 +3V3 /dac/VAD 10k
XUC1 /dac/DP0 /dac/DN0 /dac/CO0 +5VA /dac/DP1 /dac/DN1 /dac/CO1 /dac/VAD /dac/VAB /dac/VAB /dac/V2R5 /dac/V25 /dac/V25 GND OPA_QUAD
CD1 +5VA GND 100n
RVA2 /dac/VAD GND 10k
XUREF1 /dac/V2R5 GND LM4040_25
RRF1 +5VA /dac/V2R5 2.49k
RDI02 /dac/DP0 /dac/V25 10k
RDI01 DAC_I /dac/DP0 10k
RDI03 /dac/VAB /dac/DN0 10k
RDI04 /dac/DN0 /dac/CO0 10k
RDO11 /dac/CO1 CSIG1 100
RDO01 /dac/CO0 CSIG0 100
RDI13 /dac/VAB /dac/DN1 10k
RDI11 DAC_Q /dac/DP1 10k
RDI12 /dac/DP1 /dac/V25 10k
RDI14 /dac/DN1 /dac/CO1 10k
CDV1 /dac/V25 GND 100n
CDV0 /dac/V25 GND 100n
CAI1 ADC1 GND 330p
RAI2 RO2 ADC2 1k
RAI6 RO6 ADC6 1k
CAI5 ADC5 GND 330p
CAI2 ADC2 GND 330p
CAI7 ADC7 GND 330p
RAI3 RO3 ADC3 1k
CAI3 ADC3 GND 330p
CAI6 ADC6 GND 330p
RAI7 RO7 ADC7 1k
CAI0 ADC0 GND 330p
RAI0 RO0 ADC0 1k
RAI1 RO1 ADC1 1k
RAI4 RO4 ADC4 1k
CAI4 ADC4 GND 330p
RAI5 RO5 ADC5 1k
RESR1 +5VA /power/ESR 1
CJ1 /power/VJ1 GND 10u
CJ2 +5VA GND 10u
CJ3 /power/ESR GND 10u
RPU1 +3V3 SCL 4.7k
RPU2 +3V3 SDA 4.7k
.end
