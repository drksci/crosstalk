.title KiCad schematic
.include "/home/user/dlnn/hw/board/lib/dlnn_sim.lib"
CB4 VREF25 GND 10u
CB3 +3V3 GND 10u
CDIB0 +5VA GND 100n
XUIB0 /line0/RC /line0/IB /line0/IB +5VA /line1/RC /line1/IB /line1/IB /power/V2R5 VREF25 VREF25 GND /power/PK_UIB0_4 /power/PK_UIB0_4 GND OPA_QUAD
CB1 +5VA GND 10u
CB2 +5VA GND 10u
XUTR1 GND MIRB unconnected-_UTR1B-C2-Pad3_ unconnected-_UTR1B-E2-Pad4_ unconnected-_UTR1B-B2-Pad5_ MIRB DUAL_NPN
RMIR1 +5VA MIRB 4.32k
RPD1 SH_CLK GND 10k
RREF1 +5VA /power/V2R5 2.49k
XUREF1 /power/V2R5 GND LM4040_25
CREF1 /power/V2R5 GND 100n
CP0 /line0/RC GND 330p
RP0 SIG0 /line0/RC 1k
RS0 /line0/IB /line0/N0 1k
XL0_10 Net-_C0_9-Pad1_ Net-_C0_10-Pad1_ IND_FH1812
C0_9 Net-_C0_9-Pad1_ GND 120p
XL0_6 Net-_C0_5-Pad1_ Net-_C0_6-Pad1_ IND_FH1812
C0_6 Net-_C0_6-Pad1_ GND 120p
XL0_9 /line0/N8 Net-_C0_9-Pad1_ IND_FH1812
C0_8 /line0/N8 GND 120p
XL0_8 Net-_C0_7-Pad1_ /line0/N8 IND_FH1812
XL0_7 Net-_C0_6-Pad1_ Net-_C0_7-Pad1_ IND_FH1812
C0_7 Net-_C0_7-Pad1_ GND 120p
C0_10 Net-_C0_10-Pad1_ GND 120p
XL0_11 Net-_C0_10-Pad1_ Net-_C0_11-Pad1_ IND_FH1812
XL0_1 /line0/N0 Net-_C0_1-Pad1_ IND_FH1812
C0_1 Net-_C0_1-Pad1_ GND 120p
XL0_3 Net-_C0_2-Pad1_ Net-_C0_3-Pad1_ IND_FH1812
C0_3 Net-_C0_3-Pad1_ GND 120p
XL0_2 Net-_C0_1-Pad1_ Net-_C0_2-Pad1_ IND_FH1812
C0_2 Net-_C0_2-Pad1_ GND 120p
XL0_4 Net-_C0_3-Pad1_ Net-_C0_4-Pad1_ IND_FH1812
XL0_5 Net-_C0_4-Pad1_ Net-_C0_5-Pad1_ IND_FH1812
C0_4 Net-_C0_4-Pad1_ GND 120p
C0_5 Net-_C0_5-Pad1_ GND 120p
C0_0_1 /line0/N0 GND 30p
C0_0_2 /line0/N0 GND 30p
XL0_30 Net-_C0_29-Pad1_ Net-_C0_30-Pad1_ IND_FH1812
C0_29 Net-_C0_29-Pad1_ GND 120p
C0_31 Net-_C0_31-Pad1_ GND 120p
XL0_32 Net-_C0_31-Pad1_ /line0/N32 IND_FH1812
XL0_33 /line0/N32 Net-_C0_33-Pad1_ IND_FH1812
C0_32 /line0/N32 GND 120p
XL0_31 Net-_C0_30-Pad1_ Net-_C0_31-Pad1_ IND_FH1812
C0_30 Net-_C0_30-Pad1_ GND 120p
XL0_29 /line0/N28 Net-_C0_29-Pad1_ IND_FH1812
XL0_34 Net-_C0_33-Pad1_ Net-_C0_34-Pad1_ IND_FH1812
C0_34 Net-_C0_34-Pad1_ GND 120p
C0_36 Net-_C0_36-Pad1_ GND 120p
XL0_37 Net-_C0_36-Pad1_ Net-_C0_37-Pad1_ IND_FH1812
XL0_38 Net-_C0_37-Pad1_ Net-_C0_38-Pad1_ IND_FH1812
C0_37 Net-_C0_37-Pad1_ GND 120p
XL0_36 Net-_C0_35-Pad1_ Net-_C0_36-Pad1_ IND_FH1812
XL0_35 Net-_C0_34-Pad1_ Net-_C0_35-Pad1_ IND_FH1812
C0_35 Net-_C0_35-Pad1_ GND 120p
C0_38 Net-_C0_38-Pad1_ GND 120p
XUTA0 /line0/N0 T0_0 T0_0 +5VA /line0/N16 T0_2 T0_2 /line0/N32 T0_4 T0_4 /line0/N48 T0_6 T0_6 GND OPA_QUAD
XL0_39 Net-_C0_38-Pad1_ Net-_C0_39-Pad1_ IND_FH1812
C0_33 Net-_C0_33-Pad1_ GND 120p
C0_11 Net-_C0_11-Pad1_ GND 120p
C0_13 Net-_C0_13-Pad1_ GND 120p
XL0_14 Net-_C0_13-Pad1_ Net-_C0_14-Pad1_ IND_FH1812
C0_14 Net-_C0_14-Pad1_ GND 120p
XL0_15 Net-_C0_14-Pad1_ Net-_C0_15-Pad1_ IND_FH1812
XL0_13 Net-_C0_12-Pad1_ Net-_C0_13-Pad1_ IND_FH1812
XL0_12 Net-_C0_11-Pad1_ Net-_C0_12-Pad1_ IND_FH1812
C0_12 Net-_C0_12-Pad1_ GND 120p
XL0_22 Net-_C0_21-Pad1_ Net-_C0_22-Pad1_ IND_FH1812
C0_21 Net-_C0_21-Pad1_ GND 120p
XL0_48 Net-_C0_47-Pad1_ /line0/N48 IND_FH1812
C0_51 Net-_C0_51-Pad1_ GND 120p
XL0_51 Net-_C0_50-Pad1_ Net-_C0_51-Pad1_ IND_FH1812
C0_49 Net-_C0_49-Pad1_ GND 120p
XL0_23 Net-_C0_22-Pad1_ Net-_C0_23-Pad1_ IND_FH1812
C0_22 Net-_C0_22-Pad1_ GND 120p
C0_23 Net-_C0_23-Pad1_ GND 120p
C0_20 Net-_C0_20-Pad1_ GND 120p
XL0_21 Net-_C0_20-Pad1_ Net-_C0_21-Pad1_ IND_FH1812
XL0_20 Net-_C0_19-Pad1_ Net-_C0_20-Pad1_ IND_FH1812
XL0_49 /line0/N48 Net-_C0_49-Pad1_ IND_FH1812
C0_48 /line0/N48 GND 120p
XL0_50 Net-_C0_49-Pad1_ Net-_C0_50-Pad1_ IND_FH1812
C0_50 Net-_C0_50-Pad1_ GND 120p
XL0_41 /line0/N40 Net-_C0_41-Pad1_ IND_FH1812
C0_40 /line0/N40 GND 120p
C0_42 Net-_C0_42-Pad1_ GND 120p
XL0_43 Net-_C0_42-Pad1_ Net-_C0_43-Pad1_ IND_FH1812
XL0_42 Net-_C0_41-Pad1_ Net-_C0_42-Pad1_ IND_FH1812
C0_41 Net-_C0_41-Pad1_ GND 120p
XL0_40 Net-_C0_39-Pad1_ /line0/N40 IND_FH1812
CDTA0 +5VA GND 100n
C0_39 Net-_C0_39-Pad1_ GND 120p
XUTB0 /line0/N8 T0_1 T0_1 +5VA /line0/N24 T0_3 T0_3 /line0/N40 T0_5 T0_5 /line0/N56 T0_7 T0_7 GND OPA_QUAD
XL0_18 Net-_C0_17-Pad1_ Net-_C0_18-Pad1_ IND_FH1812
C0_17 Net-_C0_17-Pad1_ GND 120p
XL0_17 /line0/N16 Net-_C0_17-Pad1_ IND_FH1812
C0_16 /line0/N16 GND 120p
C0_15 Net-_C0_15-Pad1_ GND 120p
XL0_16 Net-_C0_15-Pad1_ /line0/N16 IND_FH1812
C0_19 Net-_C0_19-Pad1_ GND 120p
C0_18 Net-_C0_18-Pad1_ GND 120p
XL0_19 Net-_C0_18-Pad1_ Net-_C0_19-Pad1_ IND_FH1812
C0_28 /line0/N28 GND 120p
XL0_24 Net-_C0_23-Pad1_ /line0/N24 IND_FH1812
C0_26 Net-_C0_26-Pad1_ GND 120p
XL0_27 Net-_C0_26-Pad1_ Net-_C0_27-Pad1_ IND_FH1812
C0_27 Net-_C0_27-Pad1_ GND 120p
XL0_28 Net-_C0_27-Pad1_ /line0/N28 IND_FH1812
C0_24 /line0/N24 GND 120p
XL0_25 /line0/N24 Net-_C0_25-Pad1_ IND_FH1812
C0_25 Net-_C0_25-Pad1_ GND 120p
XL0_26 Net-_C0_25-Pad1_ Net-_C0_26-Pad1_ IND_FH1812
C0_53 Net-_C0_53-Pad1_ GND 120p
XL0_54 Net-_C0_53-Pad1_ Net-_C0_54-Pad1_ IND_FH1812
XL0_55 Net-_C0_54-Pad1_ Net-_C0_55-Pad1_ IND_FH1812
C0_54 Net-_C0_54-Pad1_ GND 120p
XL0_53 Net-_C0_52-Pad1_ Net-_C0_53-Pad1_ IND_FH1812
XL0_52 Net-_C0_51-Pad1_ Net-_C0_52-Pad1_ IND_FH1812
C0_52 Net-_C0_52-Pad1_ GND 120p
C0_55 Net-_C0_55-Pad1_ GND 120p
XL0_56 Net-_C0_55-Pad1_ /line0/N56 IND_FH1812
C0_56_1 /line0/N56 GND 30p
CDTB0 +5VA GND 100n
C0_56_2 /line0/N56 GND 30p
RT0 /line0/N56 VREF25 1k
XL0_47 Net-_C0_46-Pad1_ Net-_C0_47-Pad1_ IND_FH1812
C0_46 Net-_C0_46-Pad1_ GND 120p
C0_44 Net-_C0_44-Pad1_ GND 120p
C0_45 Net-_C0_45-Pad1_ GND 120p
XL0_46 Net-_C0_45-Pad1_ Net-_C0_46-Pad1_ IND_FH1812
XL0_45 Net-_C0_44-Pad1_ Net-_C0_45-Pad1_ IND_FH1812
C0_47 Net-_C0_47-Pad1_ GND 120p
XL0_44 Net-_C0_43-Pad1_ Net-_C0_44-Pad1_ IND_FH1812
C0_43 Net-_C0_43-Pad1_ GND 120p
CP1 /line1/RC GND 330p
RP1 SIG1 /line1/RC 1k
RS1 /line1/IB /line1/N0 1k
XL1_10 Net-_C1_9-Pad1_ Net-_C1_10-Pad1_ IND_FH1812
C1_9 Net-_C1_9-Pad1_ GND 120p
XL1_6 Net-_C1_5-Pad1_ Net-_C1_6-Pad1_ IND_FH1812
C1_6 Net-_C1_6-Pad1_ GND 120p
XL1_9 /line1/N8 Net-_C1_9-Pad1_ IND_FH1812
C1_8 /line1/N8 GND 120p
XL1_8 Net-_C1_7-Pad1_ /line1/N8 IND_FH1812
XL1_7 Net-_C1_6-Pad1_ Net-_C1_7-Pad1_ IND_FH1812
C1_7 Net-_C1_7-Pad1_ GND 120p
C1_10 Net-_C1_10-Pad1_ GND 120p
XL1_11 Net-_C1_10-Pad1_ Net-_C1_11-Pad1_ IND_FH1812
XL1_1 /line1/N0 Net-_C1_1-Pad1_ IND_FH1812
C1_1 Net-_C1_1-Pad1_ GND 120p
XL1_3 Net-_C1_2-Pad1_ Net-_C1_3-Pad1_ IND_FH1812
C1_3 Net-_C1_3-Pad1_ GND 120p
XL1_2 Net-_C1_1-Pad1_ Net-_C1_2-Pad1_ IND_FH1812
C1_2 Net-_C1_2-Pad1_ GND 120p
XL1_4 Net-_C1_3-Pad1_ Net-_C1_4-Pad1_ IND_FH1812
XL1_5 Net-_C1_4-Pad1_ Net-_C1_5-Pad1_ IND_FH1812
C1_4 Net-_C1_4-Pad1_ GND 120p
C1_5 Net-_C1_5-Pad1_ GND 120p
C1_0_1 /line1/N0 GND 30p
C1_0_2 /line1/N0 GND 30p
XL1_30 Net-_C1_29-Pad1_ Net-_C1_30-Pad1_ IND_FH1812
C1_29 Net-_C1_29-Pad1_ GND 120p
C1_31 Net-_C1_31-Pad1_ GND 120p
XL1_32 Net-_C1_31-Pad1_ /line1/N32 IND_FH1812
XL1_33 /line1/N32 Net-_C1_33-Pad1_ IND_FH1812
C1_32 /line1/N32 GND 120p
XL1_31 Net-_C1_30-Pad1_ Net-_C1_31-Pad1_ IND_FH1812
C1_30 Net-_C1_30-Pad1_ GND 120p
XL1_29 /line1/N28 Net-_C1_29-Pad1_ IND_FH1812
XL1_34 Net-_C1_33-Pad1_ Net-_C1_34-Pad1_ IND_FH1812
C1_34 Net-_C1_34-Pad1_ GND 120p
C1_36 Net-_C1_36-Pad1_ GND 120p
XL1_37 Net-_C1_36-Pad1_ Net-_C1_37-Pad1_ IND_FH1812
XL1_38 Net-_C1_37-Pad1_ Net-_C1_38-Pad1_ IND_FH1812
C1_37 Net-_C1_37-Pad1_ GND 120p
XL1_36 Net-_C1_35-Pad1_ Net-_C1_36-Pad1_ IND_FH1812
XL1_35 Net-_C1_34-Pad1_ Net-_C1_35-Pad1_ IND_FH1812
C1_35 Net-_C1_35-Pad1_ GND 120p
C1_38 Net-_C1_38-Pad1_ GND 120p
XUTA1 /line1/N0 T1_0 T1_0 +5VA /line1/N16 T1_2 T1_2 /line1/N32 T1_4 T1_4 /line1/N48 T1_6 T1_6 GND OPA_QUAD
XL1_39 Net-_C1_38-Pad1_ Net-_C1_39-Pad1_ IND_FH1812
C1_33 Net-_C1_33-Pad1_ GND 120p
C1_11 Net-_C1_11-Pad1_ GND 120p
C1_13 Net-_C1_13-Pad1_ GND 120p
XL1_14 Net-_C1_13-Pad1_ Net-_C1_14-Pad1_ IND_FH1812
C1_14 Net-_C1_14-Pad1_ GND 120p
XL1_15 Net-_C1_14-Pad1_ Net-_C1_15-Pad1_ IND_FH1812
XL1_13 Net-_C1_12-Pad1_ Net-_C1_13-Pad1_ IND_FH1812
XL1_12 Net-_C1_11-Pad1_ Net-_C1_12-Pad1_ IND_FH1812
C1_12 Net-_C1_12-Pad1_ GND 120p
XL1_22 Net-_C1_21-Pad1_ Net-_C1_22-Pad1_ IND_FH1812
C1_21 Net-_C1_21-Pad1_ GND 120p
XL1_48 Net-_C1_47-Pad1_ /line1/N48 IND_FH1812
C1_51 Net-_C1_51-Pad1_ GND 120p
XL1_51 Net-_C1_50-Pad1_ Net-_C1_51-Pad1_ IND_FH1812
C1_49 Net-_C1_49-Pad1_ GND 120p
XL1_23 Net-_C1_22-Pad1_ Net-_C1_23-Pad1_ IND_FH1812
C1_22 Net-_C1_22-Pad1_ GND 120p
C1_23 Net-_C1_23-Pad1_ GND 120p
C1_20 Net-_C1_20-Pad1_ GND 120p
XL1_21 Net-_C1_20-Pad1_ Net-_C1_21-Pad1_ IND_FH1812
XL1_20 Net-_C1_19-Pad1_ Net-_C1_20-Pad1_ IND_FH1812
XL1_49 /line1/N48 Net-_C1_49-Pad1_ IND_FH1812
C1_48 /line1/N48 GND 120p
XL1_50 Net-_C1_49-Pad1_ Net-_C1_50-Pad1_ IND_FH1812
C1_50 Net-_C1_50-Pad1_ GND 120p
XL1_41 /line1/N40 Net-_C1_41-Pad1_ IND_FH1812
C1_40 /line1/N40 GND 120p
C1_42 Net-_C1_42-Pad1_ GND 120p
XL1_43 Net-_C1_42-Pad1_ Net-_C1_43-Pad1_ IND_FH1812
XL1_42 Net-_C1_41-Pad1_ Net-_C1_42-Pad1_ IND_FH1812
C1_41 Net-_C1_41-Pad1_ GND 120p
XL1_40 Net-_C1_39-Pad1_ /line1/N40 IND_FH1812
CDTA1 +5VA GND 100n
C1_39 Net-_C1_39-Pad1_ GND 120p
XUTB1 /line1/N8 T1_1 T1_1 +5VA /line1/N24 T1_3 T1_3 /line1/N40 T1_5 T1_5 /line1/N56 T1_7 T1_7 GND OPA_QUAD
XL1_18 Net-_C1_17-Pad1_ Net-_C1_18-Pad1_ IND_FH1812
C1_17 Net-_C1_17-Pad1_ GND 120p
XL1_17 /line1/N16 Net-_C1_17-Pad1_ IND_FH1812
C1_16 /line1/N16 GND 120p
C1_15 Net-_C1_15-Pad1_ GND 120p
XL1_16 Net-_C1_15-Pad1_ /line1/N16 IND_FH1812
C1_19 Net-_C1_19-Pad1_ GND 120p
C1_18 Net-_C1_18-Pad1_ GND 120p
XL1_19 Net-_C1_18-Pad1_ Net-_C1_19-Pad1_ IND_FH1812
C1_28 /line1/N28 GND 120p
XL1_24 Net-_C1_23-Pad1_ /line1/N24 IND_FH1812
C1_26 Net-_C1_26-Pad1_ GND 120p
XL1_27 Net-_C1_26-Pad1_ Net-_C1_27-Pad1_ IND_FH1812
C1_27 Net-_C1_27-Pad1_ GND 120p
XL1_28 Net-_C1_27-Pad1_ /line1/N28 IND_FH1812
C1_24 /line1/N24 GND 120p
XL1_25 /line1/N24 Net-_C1_25-Pad1_ IND_FH1812
C1_25 Net-_C1_25-Pad1_ GND 120p
XL1_26 Net-_C1_25-Pad1_ Net-_C1_26-Pad1_ IND_FH1812
C1_53 Net-_C1_53-Pad1_ GND 120p
XL1_54 Net-_C1_53-Pad1_ Net-_C1_54-Pad1_ IND_FH1812
XL1_55 Net-_C1_54-Pad1_ Net-_C1_55-Pad1_ IND_FH1812
C1_54 Net-_C1_54-Pad1_ GND 120p
XL1_53 Net-_C1_52-Pad1_ Net-_C1_53-Pad1_ IND_FH1812
XL1_52 Net-_C1_51-Pad1_ Net-_C1_52-Pad1_ IND_FH1812
C1_52 Net-_C1_52-Pad1_ GND 120p
C1_55 Net-_C1_55-Pad1_ GND 120p
XL1_56 Net-_C1_55-Pad1_ /line1/N56 IND_FH1812
C1_56_1 /line1/N56 GND 30p
CDTB1 +5VA GND 100n
C1_56_2 /line1/N56 GND 30p
RT1 /line1/N56 VREF25 1k
XL1_47 Net-_C1_46-Pad1_ Net-_C1_47-Pad1_ IND_FH1812
C1_46 Net-_C1_46-Pad1_ GND 120p
C1_44 Net-_C1_44-Pad1_ GND 120p
C1_45 Net-_C1_45-Pad1_ GND 120p
XL1_46 Net-_C1_45-Pad1_ Net-_C1_46-Pad1_ IND_FH1812
XL1_45 Net-_C1_44-Pad1_ Net-_C1_45-Pad1_ IND_FH1812
C1_47 Net-_C1_47-Pad1_ GND 120p
XL1_44 Net-_C1_43-Pad1_ Net-_C1_44-Pad1_ IND_FH1812
C1_43 Net-_C1_43-Pad1_ GND 120p
RXP_6_1_3 T1_3 SN6 10k
RXP_6_1_2 T1_2 SN6 10k
RXP_6_1_6 T1_6 SN6 10k
RXP_6_1_4 T1_4 SN6 10k
RXP_6_1_5 T1_5 SN6 10k
RXN_7_0_2 T0_2 SP7 10k
RXN_7_0_1 T0_1 SP7 10k
RXN_7_0_0 T0_0 SP7 10k
RXP_7_0_5 T0_5 SN7 10k
RXP_7_1_4 T1_4 SN7 10k
RXP_7_1_3 T1_3 SN7 10k
RXP_7_1_5 T1_5 SN7 10k
RXP_7_0_7 T0_7 SN7 10k
RXP_7_1_6 T1_6 SN7 10k
RXN_7_1_0 T1_0 SP7 10k
RXN_6_0_4 T0_4 SP6 10k
RXN_6_0_3 T0_3 SP6 10k
RXN_6_0_5 T0_5 SP6 10k
RXN_6_0_6 T0_6 SP6 10k
RXN_6_0_2 T0_2 SP6 10k
RXP_1_1_4 T1_4 SN1 10k
RXP_1_1_5 T1_5 SN1 10k
RXP_2_0_7 T0_7 SN2 10k
RXP_2_1_7 T1_7 SN2 10k
RXP_2_1_2 T1_2 SN2 10k
RXP_2_1_1 T1_1 SN2 10k
RXP_2_1_6 T1_6 SN2 10k
RXP_2_1_5 T1_5 SN2 10k
RXP_2_1_4 T1_4 SN2 10k
RXP_0_1_1 T1_1 SN0 10k
RXP_0_1_2 T1_2 SN0 10k
RXP_0_1_3 T1_3 SN0 10k
RXP_0_1_0 T1_0 SN0 10k
RXP_0_0_7 T0_7 SN0 10k
RXN_3_1_7 T1_7 SP3 10k
RXN_3_0_7 T0_7 SP3 10k
RXP_3_1_3 T1_3 SN3 10k
RXP_3_1_1 T1_1 SN3 10k
RXP_3_1_2 T1_2 SN3 10k
RXP_3_1_0 T1_0 SN3 10k
RXP_1_1_0 T1_0 SN1 10k
RXP_1_1_1 T1_1 SN1 10k
RXP_1_1_3 T1_3 SN1 10k
RXP_1_1_2 T1_2 SN1 10k
RXN_5_0_1 T0_1 SP5 10k
RXN_5_0_3 T0_3 SP5 10k
RXN_5_0_2 T0_2 SP5 10k
RXP_4_1_6 T1_6 SN4 10k
RXP_4_1_7 T1_7 SN4 10k
RXP_4_1_5 T1_5 SN4 10k
RXP_4_1_4 T1_4 SN4 10k
RXP_4_1_3 T1_3 SN4 10k
RXP_5_0_7 T0_7 SN5 10k
RXN_5_1_0 T1_0 SP5 10k
RXN_5_1_1 T1_1 SP5 10k
RXN_5_1_3 T1_3 SP5 10k
RXN_5_1_2 T1_2 SP5 10k
RXP_5_1_7 T1_7 SN5 10k
RXP_5_1_6 T1_6 SN5 10k
RXP_4_1_1 T1_1 SN4 10k
RXP_4_1_2 T1_2 SN4 10k
RXN_4_0_7 T0_7 SP4 10k
RXN_1_0_2 T0_2 SP1 10k
RXN_1_0_3 T0_3 SP1 10k
RXP_2_0_0 T0_0 SN2 10k
RXN_1_0_1 T0_1 SP1 10k
RXP_2_0_1 T0_1 SN2 10k
RXP_2_0_2 T0_2 SN2 10k
RXN_1_0_4 T0_4 SP1 10k
RXN_1_0_5 T0_5 SP1 10k
RXP_2_0_3 T0_3 SN2 10k
RXP_2_0_4 T0_4 SN2 10k
RXP_2_0_5 T0_5 SN2 10k
RXP_2_0_6 T0_6 SN2 10k
RXP_0_0_1 T0_1 SN0 10k
RXP_0_0_0 T0_0 SN0 10k
RXP_0_0_2 T0_2 SN0 10k
RXP_0_0_4 T0_4 SN0 10k
RXP_0_0_5 T0_5 SN0 10k
RXP_0_0_6 T0_6 SN0 10k
RXP_0_0_3 T0_3 SN0 10k
RXN_3_0_6 T0_6 SP3 10k
RXP_3_0_1 T0_1 SN3 10k
RXN_3_0_5 T0_5 SP3 10k
RXN_3_0_4 T0_4 SP3 10k
RFP0 SP0 /ch0/OP 2.21k
CFP0 SP0 /ch0/OP 15p
XUCS0 VREF25 SP0 /ch0/OP +5VA VREF25 SN0 /ch0/ON VREF25 SP1 /ch1/OP VREF25 SN1 /ch1/ON GND OPA_QUAD
RFN0 SN0 /ch0/ON 2.21k
CFN0 SN0 /ch0/ON 15p
RB0 BIAS0 SN0 15k
CBF0 BIAS0 GND 100n
RO0 +5VA SN0 25.5k
RLD1_0 +5VA /ch0/DC1 1k
XQD0 /ch0/TAIL /ch0/ON /ch0/DC2 /ch0/TAIL /ch0/OP /ch0/DC1 DUAL_NPN
XUT0 GND MIRB /ch1/TAIL GND MIRB /ch0/TAIL DUAL_NPN
RDA4_0 /ch0/DAIN /ch0/DAO 10.5k
CDA0 /ch0/DAIN /ch0/DAO 8.2p
RLD2_0 +5VA /ch0/DC2 1k
RDA1_0 /ch0/DC1 /ch0/DAIP 20k
RDA2_0 /ch0/DAIP VREF25 10.5k
XUDA0 /ch0/DAIP /ch0/DAIN /ch0/DAO +5VA /ch0/HOLD OUT0 OUT0 /ch1/DAIP /ch1/DAIN /ch1/DAO /ch1/HOLD OUT1 OUT1 GND OPA_QUAD
RDA3_0 /ch0/DC2 /ch0/DAIN 20k
XUSH0 /ch0/DAO /ch0/HOLD SH_CLK /ch1/DAO /ch1/HOLD SH_CLK /ch2/DAO /ch2/HOLD SH_CLK /ch3/DAO /ch3/HOLD SH_CLK +5VA GND SW4066_QUAD
CDSH0 +5VA GND 100n
CH0 /ch0/HOLD GND 560p
CDCS0 +5VA GND 100n
CDDA0 +5VA GND 100n
RFP1 SP1 /ch1/OP 2.21k
CFP1 SP1 /ch1/OP 15p
CH1 /ch1/HOLD GND 560p
RFN1 SN1 /ch1/ON 2.21k
CFN1 SN1 /ch1/ON 15p
RB1 BIAS1 SN1 15k
CBF1 BIAS1 GND 100n
RO1 +5VA SN1 25.5k
RLD1_1 +5VA /ch1/DC1 1k
XQD1 /ch1/TAIL /ch1/ON /ch1/DC2 /ch1/TAIL /ch1/OP /ch1/DC1 DUAL_NPN
RDA4_1 /ch1/DAIN /ch1/DAO 10.5k
CDA1 /ch1/DAIN /ch1/DAO 8.2p
RLD2_1 +5VA /ch1/DC2 1k
RDA1_1 /ch1/DC1 /ch1/DAIP 20k
RDA2_1 /ch1/DAIP VREF25 10.5k
RDA3_1 /ch1/DC2 /ch1/DAIN 20k
RFP2 SP2 /ch2/OP 2.21k
CFP2 SP2 /ch2/OP 15p
XUCS1 VREF25 SP2 /ch2/OP +5VA VREF25 SN2 /ch2/ON VREF25 SP3 /ch3/OP VREF25 SN3 /ch3/ON GND OPA_QUAD
RFN2 SN2 /ch2/ON 2.21k
CFN2 SN2 /ch2/ON 15p
RB2 BIAS2 SN2 15k
CBF2 BIAS2 GND 100n
RO2 +5VA SN2 25.5k
RLD1_2 +5VA /ch2/DC1 1k
XQD2 /ch2/TAIL /ch2/ON /ch2/DC2 /ch2/TAIL /ch2/OP /ch2/DC1 DUAL_NPN
XUT1 GND MIRB /ch3/TAIL GND MIRB /ch2/TAIL DUAL_NPN
RDA4_2 /ch2/DAIN /ch2/DAO 10.5k
CDA2 /ch2/DAIN /ch2/DAO 8.2p
RLD2_2 +5VA /ch2/DC2 1k
RDA1_2 /ch2/DC1 /ch2/DAIP 20k
RDA2_2 /ch2/DAIP VREF25 10.5k
XUDA1 /ch2/DAIP /ch2/DAIN /ch2/DAO +5VA /ch2/HOLD OUT2 OUT2 /ch3/DAIP /ch3/DAIN /ch3/DAO /ch3/HOLD OUT3 OUT3 GND OPA_QUAD
RDA3_2 /ch2/DC2 /ch2/DAIN 20k
CDDA1 +5VA GND 100n
CH2 /ch2/HOLD GND 560p
CDCS1 +5VA GND 100n
RFP3 SP3 /ch3/OP 2.21k
CFP3 SP3 /ch3/OP 15p
CH3 /ch3/HOLD GND 560p
RFN3 SN3 /ch3/ON 2.21k
CFN3 SN3 /ch3/ON 15p
RB3 BIAS3 SN3 15k
CBF3 BIAS3 GND 100n
RO3 +5VA SN3 25.5k
RLD1_3 +5VA /ch3/DC1 1k
XQD3 /ch3/TAIL /ch3/ON /ch3/DC2 /ch3/TAIL /ch3/OP /ch3/DC1 DUAL_NPN
RDA4_3 /ch3/DAIN /ch3/DAO 10.5k
CDA3 /ch3/DAIN /ch3/DAO 8.2p
RLD2_3 +5VA /ch3/DC2 1k
RDA1_3 /ch3/DC1 /ch3/DAIP 20k
RDA2_3 /ch3/DAIP VREF25 10.5k
RDA3_3 /ch3/DC2 /ch3/DAIN 20k
RFP4 SP4 /ch4/OP 2.21k
CFP4 SP4 /ch4/OP 15p
XUCS2 VREF25 SP4 /ch4/OP +5VA VREF25 SN4 /ch4/ON VREF25 SP5 /ch5/OP VREF25 SN5 /ch5/ON GND OPA_QUAD
RFN4 SN4 /ch4/ON 2.21k
CFN4 SN4 /ch4/ON 15p
RB4 BIAS4 SN4 15k
CBF4 BIAS4 GND 100n
RO4 +5VA SN4 25.5k
RLD1_4 +5VA /ch4/DC1 1k
XQD4 /ch4/TAIL /ch4/ON /ch4/DC2 /ch4/TAIL /ch4/OP /ch4/DC1 DUAL_NPN
XUT2 GND MIRB /ch5/TAIL GND MIRB /ch4/TAIL DUAL_NPN
RDA4_4 /ch4/DAIN /ch4/DAO 10.5k
CDA4 /ch4/DAIN /ch4/DAO 8.2p
RLD2_4 +5VA /ch4/DC2 1k
RDA1_4 /ch4/DC1 /ch4/DAIP 20k
RDA2_4 /ch4/DAIP VREF25 10.5k
XUDA2 /ch4/DAIP /ch4/DAIN /ch4/DAO +5VA /ch4/HOLD OUT4 OUT4 /ch5/DAIP /ch5/DAIN /ch5/DAO /ch5/HOLD OUT5 OUT5 GND OPA_QUAD
RDA3_4 /ch4/DC2 /ch4/DAIN 20k
XUSH1 /ch4/DAO /ch4/HOLD SH_CLK /ch5/DAO /ch5/HOLD SH_CLK /ch6/DAO /ch6/HOLD SH_CLK /ch7/DAO /ch7/HOLD SH_CLK +5VA GND SW4066_QUAD
CDSH1 +5VA GND 100n
CH4 /ch4/HOLD GND 560p
CDCS2 +5VA GND 100n
CDDA2 +5VA GND 100n
RFP5 SP5 /ch5/OP 2.21k
CFP5 SP5 /ch5/OP 15p
CH5 /ch5/HOLD GND 560p
RFN5 SN5 /ch5/ON 2.21k
CFN5 SN5 /ch5/ON 15p
RB5 BIAS5 SN5 15k
CBF5 BIAS5 GND 100n
RO5 +5VA SN5 25.5k
RLD1_5 +5VA /ch5/DC1 1k
XQD5 /ch5/TAIL /ch5/ON /ch5/DC2 /ch5/TAIL /ch5/OP /ch5/DC1 DUAL_NPN
RDA4_5 /ch5/DAIN /ch5/DAO 10.5k
CDA5 /ch5/DAIN /ch5/DAO 8.2p
RLD2_5 +5VA /ch5/DC2 1k
RDA1_5 /ch5/DC1 /ch5/DAIP 20k
RDA2_5 /ch5/DAIP VREF25 10.5k
RDA3_5 /ch5/DC2 /ch5/DAIN 20k
RFP6 SP6 /ch6/OP 2.21k
CFP6 SP6 /ch6/OP 15p
XUCS3 VREF25 SP6 /ch6/OP +5VA VREF25 SN6 /ch6/ON VREF25 SP7 /ch7/OP VREF25 SN7 /ch7/ON GND OPA_QUAD
RFN6 SN6 /ch6/ON 2.21k
CFN6 SN6 /ch6/ON 15p
RB6 BIAS6 SN6 15k
CBF6 BIAS6 GND 100n
RO6 +5VA SN6 25.5k
RLD1_6 +5VA /ch6/DC1 1k
XQD6 /ch6/TAIL /ch6/ON /ch6/DC2 /ch6/TAIL /ch6/OP /ch6/DC1 DUAL_NPN
XUT3 GND MIRB /ch7/TAIL GND MIRB /ch6/TAIL DUAL_NPN
RDA4_6 /ch6/DAIN /ch6/DAO 10.5k
CDA6 /ch6/DAIN /ch6/DAO 8.2p
RLD2_6 +5VA /ch6/DC2 1k
RDA1_6 /ch6/DC1 /ch6/DAIP 20k
RDA2_6 /ch6/DAIP VREF25 10.5k
XUDA3 /ch6/DAIP /ch6/DAIN /ch6/DAO +5VA /ch6/HOLD OUT6 OUT6 /ch7/DAIP /ch7/DAIN /ch7/DAO /ch7/HOLD OUT7 OUT7 GND OPA_QUAD
RDA3_6 /ch6/DC2 /ch6/DAIN 20k
CDDA3 +5VA GND 100n
CH6 /ch6/HOLD GND 560p
CDCS3 +5VA GND 100n
RFP7 SP7 /ch7/OP 2.21k
CFP7 SP7 /ch7/OP 15p
CH7 /ch7/HOLD GND 560p
RFN7 SN7 /ch7/ON 2.21k
CFN7 SN7 /ch7/ON 15p
RB7 BIAS7 SN7 15k
CBF7 BIAS7 GND 100n
RO7 +5VA SN7 25.5k
RLD1_7 +5VA /ch7/DC1 1k
XQD7 /ch7/TAIL /ch7/ON /ch7/DC2 /ch7/TAIL /ch7/OP /ch7/DC1 DUAL_NPN
RDA4_7 /ch7/DAIN /ch7/DAO 10.5k
CDA7 /ch7/DAIN /ch7/DAO 8.2p
RLD2_7 +5VA /ch7/DC2 1k
RDA1_7 /ch7/DC1 /ch7/DAIP 20k
RDA2_7 /ch7/DAIP VREF25 10.5k
RDA3_7 /ch7/DC2 /ch7/DAIN 20k
RID2 +3V3 /connectors/TID2 10k
RID0 +3V3 /connectors/TID0 10k
RID1 +3V3 /connectors/TID1 10k
XUDAC1 +3V3 /connectors/SCL1 /connectors/SDA1 GND unconnected-_UDAC1-RDY/_BSY-Pad5_ BIAS4 BIAS5 BIAS6 BIAS7 GND DAC4_IDEAL
CDDAC1 +3V3 GND 100n
CDDAC0 +3V3 GND 100n
XUDAC0 +3V3 /connectors/SCL0 /connectors/SDA0 GND unconnected-_UDAC0-RDY/_BSY-Pad5_ BIAS0 BIAS1 BIAS2 BIAS3 GND DAC4_IDEAL
CDMUX1 +3V3 GND 100n
RPU3 +3V3 /connectors/SDA1 10k
RPU4 +3V3 /connectors/SCL1 10k
RPU1 +3V3 /connectors/SDA0 10k
RPU2 +3V3 /connectors/SCL0 10k
.end
