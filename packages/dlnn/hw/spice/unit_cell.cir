* hw/spice/unit_cell.cir : REFERENCE layer-1 unit cell (2 input lines x 8 taps, d=1, ONE output), regenerated by
* dlnn.tiers.circuit.write_reference_netlist(); the tier generates the real netlists from model.npz.
* Run from this directory:  cd hw/spice && ngspice -b unit_cell.cir
* DLNN layer-1 unit cell: 2 input line(s) x 8 taps (d=1), outputs [0]
* GENERIC textbook models only: RLC coax (L=250 nH/m, C=100 pF/m, constant R) and a generic NPN diff pair; not vendor models, no measured hardware.
* GENERATED by dlnn.tiers.circuit - do not hand-edit
.param coax_r=1.84206807
.include coax_rg58.lib
.include diffpair.lib
Vcc vcc 0 DC 5
Vcm cm 0 DC 2
Vin0 in0 0 PWL(0 0 1e-09 0.5 1e-08 0.5 1.1e-08 -0.5 2e-08 -0.5 2.1e-08 -0.5
+ 3e-08 -0.5 3.1e-08 0 4e-08 0 4.1e-08 0 5e-08 0 5.1e-08 0.5
+ 6e-08 0.5 6.1e-08 0.5 7e-08 0.5 7.1e-08 -0.5 8e-08 -0.5 8.1e-08 0.5
+ 9e-08 0.5 9.1e-08 -0.5 1e-07 -0.5 1.01e-07 -0.5 1.1e-07 -0.5 1.11e-07 0.5
+ 1.2e-07 0.5 1.21e-07 0.5 1.3e-07 0.5 1.31e-07 -0.5 1.4e-07 -0.5 1.41e-07 -0.5
+ 1.5e-07 -0.5 1.51e-07 -0.5 1.6e-07 -0.5 1.61e-07 -0.5 1.7e-07 -0.5 1.71e-07 0.5
+ 1.8e-07 0.5 1.81e-07 0 1.9e-07 0 1.91e-07 0 2e-07 0 2.01e-07 -0.5
+ 2.1e-07 -0.5 2.11e-07 0 2.2e-07 0 2.21e-07 -0.5 2.3e-07 -0.5 2.31e-07 0.5
+ 2.4e-07 0.5)
Vin1 in1 0 PWL(0 0 1e-09 0 1e-08 0 1.1e-08 -0.5 2e-08 -0.5 2.1e-08 -0.5
+ 3e-08 -0.5 3.1e-08 0.5 4e-08 0.5 4.1e-08 0 5e-08 0 5.1e-08 0
+ 6e-08 0 6.1e-08 -0.5 7e-08 -0.5 7.1e-08 -0.5 8e-08 -0.5 8.1e-08 0
+ 9e-08 0 9.1e-08 0 1e-07 0 1.01e-07 0 1.1e-07 0 1.11e-07 0.5
+ 1.2e-07 0.5 1.21e-07 0.5 1.3e-07 0.5 1.31e-07 -0.5 1.4e-07 -0.5 1.41e-07 0
+ 1.5e-07 0 1.51e-07 0 1.6e-07 0 1.61e-07 -0.5 1.7e-07 -0.5 1.71e-07 -0.5
+ 1.8e-07 -0.5 1.81e-07 0 1.9e-07 0 1.91e-07 0.5 2e-07 0.5 2.01e-07 -0.5
+ 2.1e-07 -0.5 2.11e-07 0.5 2.2e-07 0.5 2.21e-07 0 2.3e-07 0 2.31e-07 -0.5
+ 2.4e-07 -0.5)
* tap 0,0: direct connection (zero delay)
Xline_0_1 in0 tap_0_1 coax_rg58 len=2
Rterm_0_1 tap_0_1 0 50
Xline_0_2 in0 tap_0_2 coax_rg58 len=4
Rterm_0_2 tap_0_2 0 50
Xline_0_4 in0 tap_0_4 coax_rg58 len=8
Rterm_0_4 tap_0_4 0 50
Xline_0_7 in0 tap_0_7 coax_rg58 len=14
Rterm_0_7 tap_0_7 0 50
* tap 1,0: direct connection (zero delay)
Xline_1_1 in1 tap_1_1 coax_rg58 len=2
Rterm_1_1 tap_1_1 0 50
Xline_1_6 in1 tap_1_6 coax_rg58 len=12
Rterm_1_6 tap_1_6 0 50
Xline_1_7 in1 tap_1_7 coax_rg58 len=14
Rterm_1_7 tap_1_7 0 50
Etap_0_0 s0_0 0 in0 0 -1
Etap_0_1 s0_1 s0_0 tap_0_1 0 -1
Etap_0_2 s0_2 s0_1 tap_0_2 0 1
Etap_0_3 s0_3 s0_2 tap_0_4 0 -1
Etap_0_4 s0_4 s0_3 tap_0_7 0 -1
Etap_0_5 s0_5 s0_4 in1 0 1
Etap_0_6 s0_6 s0_5 tap_1_1 0 -1
Etap_0_7 s0_7 s0_6 tap_1_6 0 1
Etap_0_8 sum0 s0_7 tap_1_7 0 1
Epre0 vdp0 bn0 sum0 0 0.1036
Vb0 bn0 0 DC 0
Ep0 inp0 cm vdp0 0 0.5
En0 inn0 cm vdp0 0 -0.5
Xdp0 inp0 inn0 outp0 outn0 vcc diffpair rl=1000 iee=0.00101
Eout0 y0 0 outp0 outn0 1
Rpool0 y0 p0 1000
Cpool0 p0 0 2.4e-10
.tran 0.5n 2.4e-07 0 0.5n
.save v(y0) v(p0) v(in0) v(in1)
.end
