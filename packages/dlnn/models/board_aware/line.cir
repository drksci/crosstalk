* DLNN LC delay line, 56 sections, 1k terminated, 1.5 MHz input RC
Vin src 0 PULSE(0 1 1n 1.000e-08 1.000e-08 9.500000e-07 1)
Rs src n0 1000
Cin n0 0 1.0610e-10
Cs0 n0 0 6.000e-11
L1 n0 m1 1.200e-04
RL1 m1 n1 3
C1 n1 0 1.200e-10
L2 n1 m2 1.200e-04
RL2 m2 n2 3
C2 n2 0 1.200e-10
L3 n2 m3 1.200e-04
RL3 m3 n3 3
C3 n3 0 1.200e-10
L4 n3 m4 1.200e-04
RL4 m4 n4 3
C4 n4 0 1.200e-10
L5 n4 m5 1.200e-04
RL5 m5 n5 3
C5 n5 0 1.200e-10
L6 n5 m6 1.200e-04
RL6 m6 n6 3
C6 n6 0 1.200e-10
L7 n6 m7 1.200e-04
RL7 m7 n7 3
C7 n7 0 1.200e-10
L8 n7 m8 1.200e-04
RL8 m8 n8 3
C8 n8 0 1.200e-10
L9 n8 m9 1.200e-04
RL9 m9 n9 3
C9 n9 0 1.200e-10
L10 n9 m10 1.200e-04
RL10 m10 n10 3
C10 n10 0 1.200e-10
L11 n10 m11 1.200e-04
RL11 m11 n11 3
C11 n11 0 1.200e-10
L12 n11 m12 1.200e-04
RL12 m12 n12 3
C12 n12 0 1.200e-10
L13 n12 m13 1.200e-04
RL13 m13 n13 3
C13 n13 0 1.200e-10
L14 n13 m14 1.200e-04
RL14 m14 n14 3
C14 n14 0 1.200e-10
L15 n14 m15 1.200e-04
RL15 m15 n15 3
C15 n15 0 1.200e-10
L16 n15 m16 1.200e-04
RL16 m16 n16 3
C16 n16 0 1.200e-10
L17 n16 m17 1.200e-04
RL17 m17 n17 3
C17 n17 0 1.200e-10
L18 n17 m18 1.200e-04
RL18 m18 n18 3
C18 n18 0 1.200e-10
L19 n18 m19 1.200e-04
RL19 m19 n19 3
C19 n19 0 1.200e-10
L20 n19 m20 1.200e-04
RL20 m20 n20 3
C20 n20 0 1.200e-10
L21 n20 m21 1.200e-04
RL21 m21 n21 3
C21 n21 0 1.200e-10
L22 n21 m22 1.200e-04
RL22 m22 n22 3
C22 n22 0 1.200e-10
L23 n22 m23 1.200e-04
RL23 m23 n23 3
C23 n23 0 1.200e-10
L24 n23 m24 1.200e-04
RL24 m24 n24 3
C24 n24 0 1.200e-10
L25 n24 m25 1.200e-04
RL25 m25 n25 3
C25 n25 0 1.200e-10
L26 n25 m26 1.200e-04
RL26 m26 n26 3
C26 n26 0 1.200e-10
L27 n26 m27 1.200e-04
RL27 m27 n27 3
C27 n27 0 1.200e-10
L28 n27 m28 1.200e-04
RL28 m28 n28 3
C28 n28 0 1.200e-10
L29 n28 m29 1.200e-04
RL29 m29 n29 3
C29 n29 0 1.200e-10
L30 n29 m30 1.200e-04
RL30 m30 n30 3
C30 n30 0 1.200e-10
L31 n30 m31 1.200e-04
RL31 m31 n31 3
C31 n31 0 1.200e-10
L32 n31 m32 1.200e-04
RL32 m32 n32 3
C32 n32 0 1.200e-10
L33 n32 m33 1.200e-04
RL33 m33 n33 3
C33 n33 0 1.200e-10
L34 n33 m34 1.200e-04
RL34 m34 n34 3
C34 n34 0 1.200e-10
L35 n34 m35 1.200e-04
RL35 m35 n35 3
C35 n35 0 1.200e-10
L36 n35 m36 1.200e-04
RL36 m36 n36 3
C36 n36 0 1.200e-10
L37 n36 m37 1.200e-04
RL37 m37 n37 3
C37 n37 0 1.200e-10
L38 n37 m38 1.200e-04
RL38 m38 n38 3
C38 n38 0 1.200e-10
L39 n38 m39 1.200e-04
RL39 m39 n39 3
C39 n39 0 1.200e-10
L40 n39 m40 1.200e-04
RL40 m40 n40 3
C40 n40 0 1.200e-10
L41 n40 m41 1.200e-04
RL41 m41 n41 3
C41 n41 0 1.200e-10
L42 n41 m42 1.200e-04
RL42 m42 n42 3
C42 n42 0 1.200e-10
L43 n42 m43 1.200e-04
RL43 m43 n43 3
C43 n43 0 1.200e-10
L44 n43 m44 1.200e-04
RL44 m44 n44 3
C44 n44 0 1.200e-10
L45 n44 m45 1.200e-04
RL45 m45 n45 3
C45 n45 0 1.200e-10
L46 n45 m46 1.200e-04
RL46 m46 n46 3
C46 n46 0 1.200e-10
L47 n46 m47 1.200e-04
RL47 m47 n47 3
C47 n47 0 1.200e-10
L48 n47 m48 1.200e-04
RL48 m48 n48 3
C48 n48 0 1.200e-10
L49 n48 m49 1.200e-04
RL49 m49 n49 3
C49 n49 0 1.200e-10
L50 n49 m50 1.200e-04
RL50 m50 n50 3
C50 n50 0 1.200e-10
L51 n50 m51 1.200e-04
RL51 m51 n51 3
C51 n51 0 1.200e-10
L52 n51 m52 1.200e-04
RL52 m52 n52 3
C52 n52 0 1.200e-10
L53 n52 m53 1.200e-04
RL53 m53 n53 3
C53 n53 0 1.200e-10
L54 n53 m54 1.200e-04
RL54 m54 n54 3
C54 n54 0 1.200e-10
L55 n54 m55 1.200e-04
RL55 m55 n55 3
C55 n55 0 1.200e-10
L56 n55 m56 1.200e-04
RL56 m56 n56 3
C56 n56 0 6.000e-11
Rt n56 0 1000
.tran 2n 2.400e-05 0 2n
.control
run
set wr_vecnames
option numdgt=7
wrdata OUT.txt v(n0) v(n8) v(n16) v(n24) v(n32) v(n40) v(n48) v(n56)
.endc
.end
