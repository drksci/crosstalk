.title KiCad schematic
.include "/home/user/dlnn/hw/board/lib/dlnn_sim.lib"
XUIB0 /line0/RC /line0/IB /line0/IB +5VA /line1/RC /line1/IB /line1/IB /line2/RC /line2/IB /line2/IB /line3/RC /line3/IB /line3/IB GND OPA_QUAD
XUIB1 /line4/RC /line4/IB /line4/IB +5VA /line5/RC /line5/IB /line5/IB /line6/RC /line6/IB /line6/IB /line7/RC /line7/IB /line7/IB GND OPA_QUAD
CDIB0 +5VA GND 100n
CDIB1 +5VA GND 100n
XUTR1 GND MIRB unconnected-_UTR1B-C2-Pad3_ unconnected-_UTR1B-E2-Pad4_ unconnected-_UTR1B-B2-Pad5_ MIRB DUAL_NPN
XUVR1 /power/V2R5 VREF25 VREF25 +5VA GND /power/PK_UVR1_2 /power/PK_UVR1_2 GND /power/PK_UVR1_3 /power/PK_UVR1_3 GND /power/PK_UVR1_4 /power/PK_UVR1_4 GND OPA_QUAD
RREF1 +5VA /power/V2R5 2.49k
CREF1 /power/V2R5 GND 100n
CB1 +5VA GND 10u
CB2 +5VA GND 10u
CB3 +3V3 GND 10u
CB4 VREF25 GND 10u
XUREF1 /power/V2R5 GND LM4040_25
RMIR1 +5VA MIRB 4.32k
CDVR1 +5VA GND 100n
RPD1 SH_CLK GND 10k
CP0 /line0/RC GND 330p
RP0 SIG0 /line0/RC 1k
RS0 /line0/IB /line0/N0 1k
XL0_10 Net-_C0_9-Pad1_ Net-_C0_10-Pad1_ IND_FH1812
C0_9 Net-_C0_9-Pad1_ GND 120p
XL0_6 Net-_C0_5-Pad1_ Net-_C0_6-Pad1_ IND_FH1812
C0_6 Net-_C0_6-Pad1_ GND 120p
XL0_9 /line0/N8 Net-_C0_9-Pad1_ IND_FH1812
C0_8 /line0/N8 GND 120p
XL0_8 Net-_C0_7-Pad1_ /line0/N8 IND_FH1812
XL0_7 Net-_C0_6-Pad1_ Net-_C0_7-Pad1_ IND_FH1812
C0_7 Net-_C0_7-Pad1_ GND 120p
C0_10 Net-_C0_10-Pad1_ GND 120p
XL0_11 Net-_C0_10-Pad1_ Net-_C0_11-Pad1_ IND_FH1812
XL0_1 /line0/N0 Net-_C0_1-Pad1_ IND_FH1812
C0_1 Net-_C0_1-Pad1_ GND 120p
XL0_3 Net-_C0_2-Pad1_ Net-_C0_3-Pad1_ IND_FH1812
C0_3 Net-_C0_3-Pad1_ GND 120p
XL0_2 Net-_C0_1-Pad1_ Net-_C0_2-Pad1_ IND_FH1812
C0_2 Net-_C0_2-Pad1_ GND 120p
XL0_4 Net-_C0_3-Pad1_ Net-_C0_4-Pad1_ IND_FH1812
XL0_5 Net-_C0_4-Pad1_ Net-_C0_5-Pad1_ IND_FH1812
C0_4 Net-_C0_4-Pad1_ GND 120p
C0_5 Net-_C0_5-Pad1_ GND 120p
C0_0_1 /line0/N0 GND 30p
C0_0_2 /line0/N0 GND 30p
XL0_30 Net-_C0_29-Pad1_ Net-_C0_30-Pad1_ IND_FH1812
C0_29 Net-_C0_29-Pad1_ GND 120p
C0_31 Net-_C0_31-Pad1_ GND 120p
XL0_32 Net-_C0_31-Pad1_ /line0/N32 IND_FH1812
XL0_33 /line0/N32 Net-_C0_33-Pad1_ IND_FH1812
C0_32 /line0/N32 GND 120p
XL0_31 Net-_C0_30-Pad1_ Net-_C0_31-Pad1_ IND_FH1812
C0_30 Net-_C0_30-Pad1_ GND 120p
XL0_29 /line0/N28 Net-_C0_29-Pad1_ IND_FH1812
XL0_34 Net-_C0_33-Pad1_ Net-_C0_34-Pad1_ IND_FH1812
C0_34 Net-_C0_34-Pad1_ GND 120p
C0_36 Net-_C0_36-Pad1_ GND 120p
XL0_37 Net-_C0_36-Pad1_ Net-_C0_37-Pad1_ IND_FH1812
XL0_38 Net-_C0_37-Pad1_ Net-_C0_38-Pad1_ IND_FH1812
C0_37 Net-_C0_37-Pad1_ GND 120p
XL0_36 Net-_C0_35-Pad1_ Net-_C0_36-Pad1_ IND_FH1812
XL0_35 Net-_C0_34-Pad1_ Net-_C0_35-Pad1_ IND_FH1812
C0_35 Net-_C0_35-Pad1_ GND 120p
C0_38 Net-_C0_38-Pad1_ GND 120p
XUTA0 /line0/N0 T0_0 T0_0 +5VA /line0/N16 T0_2 T0_2 /line0/N32 T0_4 T0_4 /line0/N48 T0_6 T0_6 GND OPA_QUAD
XL0_39 Net-_C0_38-Pad1_ Net-_C0_39-Pad1_ IND_FH1812
C0_33 Net-_C0_33-Pad1_ GND 120p
C0_11 Net-_C0_11-Pad1_ GND 120p
C0_13 Net-_C0_13-Pad1_ GND 120p
XL0_14 Net-_C0_13-Pad1_ Net-_C0_14-Pad1_ IND_FH1812
C0_14 Net-_C0_14-Pad1_ GND 120p
XL0_15 Net-_C0_14-Pad1_ Net-_C0_15-Pad1_ IND_FH1812
XL0_13 Net-_C0_12-Pad1_ Net-_C0_13-Pad1_ IND_FH1812
XL0_12 Net-_C0_11-Pad1_ Net-_C0_12-Pad1_ IND_FH1812
C0_12 Net-_C0_12-Pad1_ GND 120p
XL0_22 Net-_C0_21-Pad1_ Net-_C0_22-Pad1_ IND_FH1812
C0_21 Net-_C0_21-Pad1_ GND 120p
XL0_48 Net-_C0_47-Pad1_ /line0/N48 IND_FH1812
C0_51 Net-_C0_51-Pad1_ GND 120p
XL0_51 Net-_C0_50-Pad1_ Net-_C0_51-Pad1_ IND_FH1812
C0_49 Net-_C0_49-Pad1_ GND 120p
XL0_23 Net-_C0_22-Pad1_ Net-_C0_23-Pad1_ IND_FH1812
C0_22 Net-_C0_22-Pad1_ GND 120p
C0_23 Net-_C0_23-Pad1_ GND 120p
C0_20 Net-_C0_20-Pad1_ GND 120p
XL0_21 Net-_C0_20-Pad1_ Net-_C0_21-Pad1_ IND_FH1812
XL0_20 Net-_C0_19-Pad1_ Net-_C0_20-Pad1_ IND_FH1812
XL0_49 /line0/N48 Net-_C0_49-Pad1_ IND_FH1812
C0_48 /line0/N48 GND 120p
XL0_50 Net-_C0_49-Pad1_ Net-_C0_50-Pad1_ IND_FH1812
C0_50 Net-_C0_50-Pad1_ GND 120p
XL0_41 /line0/N40 Net-_C0_41-Pad1_ IND_FH1812
C0_40 /line0/N40 GND 120p
C0_42 Net-_C0_42-Pad1_ GND 120p
XL0_43 Net-_C0_42-Pad1_ Net-_C0_43-Pad1_ IND_FH1812
XL0_42 Net-_C0_41-Pad1_ Net-_C0_42-Pad1_ IND_FH1812
C0_41 Net-_C0_41-Pad1_ GND 120p
XL0_40 Net-_C0_39-Pad1_ /line0/N40 IND_FH1812
CDTA0 +5VA GND 100n
C0_39 Net-_C0_39-Pad1_ GND 120p
XUTB0 /line0/N8 T0_1 T0_1 +5VA /line0/N24 T0_3 T0_3 /line0/N40 T0_5 T0_5 /line0/N56 T0_7 T0_7 GND OPA_QUAD
XL0_18 Net-_C0_17-Pad1_ Net-_C0_18-Pad1_ IND_FH1812
C0_17 Net-_C0_17-Pad1_ GND 120p
XL0_17 /line0/N16 Net-_C0_17-Pad1_ IND_FH1812
C0_16 /line0/N16 GND 120p
C0_15 Net-_C0_15-Pad1_ GND 120p
XL0_16 Net-_C0_15-Pad1_ /line0/N16 IND_FH1812
C0_19 Net-_C0_19-Pad1_ GND 120p
C0_18 Net-_C0_18-Pad1_ GND 120p
XL0_19 Net-_C0_18-Pad1_ Net-_C0_19-Pad1_ IND_FH1812
C0_28 /line0/N28 GND 120p
XL0_24 Net-_C0_23-Pad1_ /line0/N24 IND_FH1812
C0_26 Net-_C0_26-Pad1_ GND 120p
XL0_27 Net-_C0_26-Pad1_ Net-_C0_27-Pad1_ IND_FH1812
C0_27 Net-_C0_27-Pad1_ GND 120p
XL0_28 Net-_C0_27-Pad1_ /line0/N28 IND_FH1812
C0_24 /line0/N24 GND 120p
XL0_25 /line0/N24 Net-_C0_25-Pad1_ IND_FH1812
C0_25 Net-_C0_25-Pad1_ GND 120p
XL0_26 Net-_C0_25-Pad1_ Net-_C0_26-Pad1_ IND_FH1812
C0_53 Net-_C0_53-Pad1_ GND 120p
XL0_54 Net-_C0_53-Pad1_ Net-_C0_54-Pad1_ IND_FH1812
XL0_55 Net-_C0_54-Pad1_ Net-_C0_55-Pad1_ IND_FH1812
C0_54 Net-_C0_54-Pad1_ GND 120p
XL0_53 Net-_C0_52-Pad1_ Net-_C0_53-Pad1_ IND_FH1812
XL0_52 Net-_C0_51-Pad1_ Net-_C0_52-Pad1_ IND_FH1812
C0_52 Net-_C0_52-Pad1_ GND 120p
C0_55 Net-_C0_55-Pad1_ GND 120p
XL0_56 Net-_C0_55-Pad1_ /line0/N56 IND_FH1812
C0_56_1 /line0/N56 GND 30p
CDTB0 +5VA GND 100n
C0_56_2 /line0/N56 GND 30p
RT0 /line0/N56 GND 1k
XL0_47 Net-_C0_46-Pad1_ Net-_C0_47-Pad1_ IND_FH1812
C0_46 Net-_C0_46-Pad1_ GND 120p
C0_44 Net-_C0_44-Pad1_ GND 120p
C0_45 Net-_C0_45-Pad1_ GND 120p
XL0_46 Net-_C0_45-Pad1_ Net-_C0_46-Pad1_ IND_FH1812
XL0_45 Net-_C0_44-Pad1_ Net-_C0_45-Pad1_ IND_FH1812
C0_47 Net-_C0_47-Pad1_ GND 120p
XL0_44 Net-_C0_43-Pad1_ Net-_C0_44-Pad1_ IND_FH1812
C0_43 Net-_C0_43-Pad1_ GND 120p
CP1 /line1/RC GND 330p
RP1 SIG1 /line1/RC 1k
RS1 /line1/IB /line1/N0 1k
XL1_10 Net-_C1_9-Pad1_ Net-_C1_10-Pad1_ IND_FH1812
C1_9 Net-_C1_9-Pad1_ GND 120p
XL1_6 Net-_C1_5-Pad1_ Net-_C1_6-Pad1_ IND_FH1812
C1_6 Net-_C1_6-Pad1_ GND 120p
XL1_9 /line1/N8 Net-_C1_9-Pad1_ IND_FH1812
C1_8 /line1/N8 GND 120p
XL1_8 Net-_C1_7-Pad1_ /line1/N8 IND_FH1812
XL1_7 Net-_C1_6-Pad1_ Net-_C1_7-Pad1_ IND_FH1812
C1_7 Net-_C1_7-Pad1_ GND 120p
C1_10 Net-_C1_10-Pad1_ GND 120p
XL1_11 Net-_C1_10-Pad1_ Net-_C1_11-Pad1_ IND_FH1812
XL1_1 /line1/N0 Net-_C1_1-Pad1_ IND_FH1812
C1_1 Net-_C1_1-Pad1_ GND 120p
XL1_3 Net-_C1_2-Pad1_ Net-_C1_3-Pad1_ IND_FH1812
C1_3 Net-_C1_3-Pad1_ GND 120p
XL1_2 Net-_C1_1-Pad1_ Net-_C1_2-Pad1_ IND_FH1812
C1_2 Net-_C1_2-Pad1_ GND 120p
XL1_4 Net-_C1_3-Pad1_ Net-_C1_4-Pad1_ IND_FH1812
XL1_5 Net-_C1_4-Pad1_ Net-_C1_5-Pad1_ IND_FH1812
C1_4 Net-_C1_4-Pad1_ GND 120p
C1_5 Net-_C1_5-Pad1_ GND 120p
C1_0_1 /line1/N0 GND 30p
C1_0_2 /line1/N0 GND 30p
XL1_30 Net-_C1_29-Pad1_ Net-_C1_30-Pad1_ IND_FH1812
C1_29 Net-_C1_29-Pad1_ GND 120p
C1_31 Net-_C1_31-Pad1_ GND 120p
XL1_32 Net-_C1_31-Pad1_ /line1/N32 IND_FH1812
XL1_33 /line1/N32 Net-_C1_33-Pad1_ IND_FH1812
C1_32 /line1/N32 GND 120p
XL1_31 Net-_C1_30-Pad1_ Net-_C1_31-Pad1_ IND_FH1812
C1_30 Net-_C1_30-Pad1_ GND 120p
XL1_29 /line1/N28 Net-_C1_29-Pad1_ IND_FH1812
XL1_34 Net-_C1_33-Pad1_ Net-_C1_34-Pad1_ IND_FH1812
C1_34 Net-_C1_34-Pad1_ GND 120p
C1_36 Net-_C1_36-Pad1_ GND 120p
XL1_37 Net-_C1_36-Pad1_ Net-_C1_37-Pad1_ IND_FH1812
XL1_38 Net-_C1_37-Pad1_ Net-_C1_38-Pad1_ IND_FH1812
C1_37 Net-_C1_37-Pad1_ GND 120p
XL1_36 Net-_C1_35-Pad1_ Net-_C1_36-Pad1_ IND_FH1812
XL1_35 Net-_C1_34-Pad1_ Net-_C1_35-Pad1_ IND_FH1812
C1_35 Net-_C1_35-Pad1_ GND 120p
C1_38 Net-_C1_38-Pad1_ GND 120p
XUTA1 /line1/N0 T1_0 T1_0 +5VA /line1/N16 T1_2 T1_2 /line1/N32 T1_4 T1_4 /line1/N48 T1_6 T1_6 GND OPA_QUAD
XL1_39 Net-_C1_38-Pad1_ Net-_C1_39-Pad1_ IND_FH1812
C1_33 Net-_C1_33-Pad1_ GND 120p
C1_11 Net-_C1_11-Pad1_ GND 120p
C1_13 Net-_C1_13-Pad1_ GND 120p
XL1_14 Net-_C1_13-Pad1_ Net-_C1_14-Pad1_ IND_FH1812
C1_14 Net-_C1_14-Pad1_ GND 120p
XL1_15 Net-_C1_14-Pad1_ Net-_C1_15-Pad1_ IND_FH1812
XL1_13 Net-_C1_12-Pad1_ Net-_C1_13-Pad1_ IND_FH1812
XL1_12 Net-_C1_11-Pad1_ Net-_C1_12-Pad1_ IND_FH1812
C1_12 Net-_C1_12-Pad1_ GND 120p
XL1_22 Net-_C1_21-Pad1_ Net-_C1_22-Pad1_ IND_FH1812
C1_21 Net-_C1_21-Pad1_ GND 120p
XL1_48 Net-_C1_47-Pad1_ /line1/N48 IND_FH1812
C1_51 Net-_C1_51-Pad1_ GND 120p
XL1_51 Net-_C1_50-Pad1_ Net-_C1_51-Pad1_ IND_FH1812
C1_49 Net-_C1_49-Pad1_ GND 120p
XL1_23 Net-_C1_22-Pad1_ Net-_C1_23-Pad1_ IND_FH1812
C1_22 Net-_C1_22-Pad1_ GND 120p
C1_23 Net-_C1_23-Pad1_ GND 120p
C1_20 Net-_C1_20-Pad1_ GND 120p
XL1_21 Net-_C1_20-Pad1_ Net-_C1_21-Pad1_ IND_FH1812
XL1_20 Net-_C1_19-Pad1_ Net-_C1_20-Pad1_ IND_FH1812
XL1_49 /line1/N48 Net-_C1_49-Pad1_ IND_FH1812
C1_48 /line1/N48 GND 120p
XL1_50 Net-_C1_49-Pad1_ Net-_C1_50-Pad1_ IND_FH1812
C1_50 Net-_C1_50-Pad1_ GND 120p
XL1_41 /line1/N40 Net-_C1_41-Pad1_ IND_FH1812
C1_40 /line1/N40 GND 120p
C1_42 Net-_C1_42-Pad1_ GND 120p
XL1_43 Net-_C1_42-Pad1_ Net-_C1_43-Pad1_ IND_FH1812
XL1_42 Net-_C1_41-Pad1_ Net-_C1_42-Pad1_ IND_FH1812
C1_41 Net-_C1_41-Pad1_ GND 120p
XL1_40 Net-_C1_39-Pad1_ /line1/N40 IND_FH1812
CDTA1 +5VA GND 100n
C1_39 Net-_C1_39-Pad1_ GND 120p
XUTB1 /line1/N8 T1_1 T1_1 +5VA /line1/N24 T1_3 T1_3 /line1/N40 T1_5 T1_5 /line1/N56 T1_7 T1_7 GND OPA_QUAD
XL1_18 Net-_C1_17-Pad1_ Net-_C1_18-Pad1_ IND_FH1812
C1_17 Net-_C1_17-Pad1_ GND 120p
XL1_17 /line1/N16 Net-_C1_17-Pad1_ IND_FH1812
C1_16 /line1/N16 GND 120p
C1_15 Net-_C1_15-Pad1_ GND 120p
XL1_16 Net-_C1_15-Pad1_ /line1/N16 IND_FH1812
C1_19 Net-_C1_19-Pad1_ GND 120p
C1_18 Net-_C1_18-Pad1_ GND 120p
XL1_19 Net-_C1_18-Pad1_ Net-_C1_19-Pad1_ IND_FH1812
C1_28 /line1/N28 GND 120p
XL1_24 Net-_C1_23-Pad1_ /line1/N24 IND_FH1812
C1_26 Net-_C1_26-Pad1_ GND 120p
XL1_27 Net-_C1_26-Pad1_ Net-_C1_27-Pad1_ IND_FH1812
C1_27 Net-_C1_27-Pad1_ GND 120p
XL1_28 Net-_C1_27-Pad1_ /line1/N28 IND_FH1812
C1_24 /line1/N24 GND 120p
XL1_25 /line1/N24 Net-_C1_25-Pad1_ IND_FH1812
C1_25 Net-_C1_25-Pad1_ GND 120p
XL1_26 Net-_C1_25-Pad1_ Net-_C1_26-Pad1_ IND_FH1812
C1_53 Net-_C1_53-Pad1_ GND 120p
XL1_54 Net-_C1_53-Pad1_ Net-_C1_54-Pad1_ IND_FH1812
XL1_55 Net-_C1_54-Pad1_ Net-_C1_55-Pad1_ IND_FH1812
C1_54 Net-_C1_54-Pad1_ GND 120p
XL1_53 Net-_C1_52-Pad1_ Net-_C1_53-Pad1_ IND_FH1812
XL1_52 Net-_C1_51-Pad1_ Net-_C1_52-Pad1_ IND_FH1812
C1_52 Net-_C1_52-Pad1_ GND 120p
C1_55 Net-_C1_55-Pad1_ GND 120p
XL1_56 Net-_C1_55-Pad1_ /line1/N56 IND_FH1812
C1_56_1 /line1/N56 GND 30p
CDTB1 +5VA GND 100n
C1_56_2 /line1/N56 GND 30p
RT1 /line1/N56 GND 1k
XL1_47 Net-_C1_46-Pad1_ Net-_C1_47-Pad1_ IND_FH1812
C1_46 Net-_C1_46-Pad1_ GND 120p
C1_44 Net-_C1_44-Pad1_ GND 120p
C1_45 Net-_C1_45-Pad1_ GND 120p
XL1_46 Net-_C1_45-Pad1_ Net-_C1_46-Pad1_ IND_FH1812
XL1_45 Net-_C1_44-Pad1_ Net-_C1_45-Pad1_ IND_FH1812
C1_47 Net-_C1_47-Pad1_ GND 120p
XL1_44 Net-_C1_43-Pad1_ Net-_C1_44-Pad1_ IND_FH1812
C1_43 Net-_C1_43-Pad1_ GND 120p
CP2 /line2/RC GND 330p
RP2 SIG2 /line2/RC 1k
RS2 /line2/IB /line2/N0 1k
XL2_10 Net-_C2_9-Pad1_ Net-_C2_10-Pad1_ IND_FH1812
C2_9 Net-_C2_9-Pad1_ GND 120p
XL2_6 Net-_C2_5-Pad1_ Net-_C2_6-Pad1_ IND_FH1812
C2_6 Net-_C2_6-Pad1_ GND 120p
XL2_9 /line2/N8 Net-_C2_9-Pad1_ IND_FH1812
C2_8 /line2/N8 GND 120p
XL2_8 Net-_C2_7-Pad1_ /line2/N8 IND_FH1812
XL2_7 Net-_C2_6-Pad1_ Net-_C2_7-Pad1_ IND_FH1812
C2_7 Net-_C2_7-Pad1_ GND 120p
C2_10 Net-_C2_10-Pad1_ GND 120p
XL2_11 Net-_C2_10-Pad1_ Net-_C2_11-Pad1_ IND_FH1812
XL2_1 /line2/N0 Net-_C2_1-Pad1_ IND_FH1812
C2_1 Net-_C2_1-Pad1_ GND 120p
XL2_3 Net-_C2_2-Pad1_ Net-_C2_3-Pad1_ IND_FH1812
C2_3 Net-_C2_3-Pad1_ GND 120p
XL2_2 Net-_C2_1-Pad1_ Net-_C2_2-Pad1_ IND_FH1812
C2_2 Net-_C2_2-Pad1_ GND 120p
XL2_4 Net-_C2_3-Pad1_ Net-_C2_4-Pad1_ IND_FH1812
XL2_5 Net-_C2_4-Pad1_ Net-_C2_5-Pad1_ IND_FH1812
C2_4 Net-_C2_4-Pad1_ GND 120p
C2_5 Net-_C2_5-Pad1_ GND 120p
C2_0_1 /line2/N0 GND 30p
C2_0_2 /line2/N0 GND 30p
XL2_30 Net-_C2_29-Pad1_ Net-_C2_30-Pad1_ IND_FH1812
C2_29 Net-_C2_29-Pad1_ GND 120p
C2_31 Net-_C2_31-Pad1_ GND 120p
XL2_32 Net-_C2_31-Pad1_ /line2/N32 IND_FH1812
XL2_33 /line2/N32 Net-_C2_33-Pad1_ IND_FH1812
C2_32 /line2/N32 GND 120p
XL2_31 Net-_C2_30-Pad1_ Net-_C2_31-Pad1_ IND_FH1812
C2_30 Net-_C2_30-Pad1_ GND 120p
XL2_29 /line2/N28 Net-_C2_29-Pad1_ IND_FH1812
XL2_34 Net-_C2_33-Pad1_ Net-_C2_34-Pad1_ IND_FH1812
C2_34 Net-_C2_34-Pad1_ GND 120p
C2_36 Net-_C2_36-Pad1_ GND 120p
XL2_37 Net-_C2_36-Pad1_ Net-_C2_37-Pad1_ IND_FH1812
XL2_38 Net-_C2_37-Pad1_ Net-_C2_38-Pad1_ IND_FH1812
C2_37 Net-_C2_37-Pad1_ GND 120p
XL2_36 Net-_C2_35-Pad1_ Net-_C2_36-Pad1_ IND_FH1812
XL2_35 Net-_C2_34-Pad1_ Net-_C2_35-Pad1_ IND_FH1812
C2_35 Net-_C2_35-Pad1_ GND 120p
C2_38 Net-_C2_38-Pad1_ GND 120p
XUTA2 /line2/N0 T2_0 T2_0 +5VA /line2/N16 T2_2 T2_2 /line2/N32 T2_4 T2_4 /line2/N48 T2_6 T2_6 GND OPA_QUAD
XL2_39 Net-_C2_38-Pad1_ Net-_C2_39-Pad1_ IND_FH1812
C2_33 Net-_C2_33-Pad1_ GND 120p
C2_11 Net-_C2_11-Pad1_ GND 120p
C2_13 Net-_C2_13-Pad1_ GND 120p
XL2_14 Net-_C2_13-Pad1_ Net-_C2_14-Pad1_ IND_FH1812
C2_14 Net-_C2_14-Pad1_ GND 120p
XL2_15 Net-_C2_14-Pad1_ Net-_C2_15-Pad1_ IND_FH1812
XL2_13 Net-_C2_12-Pad1_ Net-_C2_13-Pad1_ IND_FH1812
XL2_12 Net-_C2_11-Pad1_ Net-_C2_12-Pad1_ IND_FH1812
C2_12 Net-_C2_12-Pad1_ GND 120p
XL2_22 Net-_C2_21-Pad1_ Net-_C2_22-Pad1_ IND_FH1812
C2_21 Net-_C2_21-Pad1_ GND 120p
XL2_48 Net-_C2_47-Pad1_ /line2/N48 IND_FH1812
C2_51 Net-_C2_51-Pad1_ GND 120p
XL2_51 Net-_C2_50-Pad1_ Net-_C2_51-Pad1_ IND_FH1812
C2_49 Net-_C2_49-Pad1_ GND 120p
XL2_23 Net-_C2_22-Pad1_ Net-_C2_23-Pad1_ IND_FH1812
C2_22 Net-_C2_22-Pad1_ GND 120p
C2_23 Net-_C2_23-Pad1_ GND 120p
C2_20 Net-_C2_20-Pad1_ GND 120p
XL2_21 Net-_C2_20-Pad1_ Net-_C2_21-Pad1_ IND_FH1812
XL2_20 Net-_C2_19-Pad1_ Net-_C2_20-Pad1_ IND_FH1812
XL2_49 /line2/N48 Net-_C2_49-Pad1_ IND_FH1812
C2_48 /line2/N48 GND 120p
XL2_50 Net-_C2_49-Pad1_ Net-_C2_50-Pad1_ IND_FH1812
C2_50 Net-_C2_50-Pad1_ GND 120p
XL2_41 /line2/N40 Net-_C2_41-Pad1_ IND_FH1812
C2_40 /line2/N40 GND 120p
C2_42 Net-_C2_42-Pad1_ GND 120p
XL2_43 Net-_C2_42-Pad1_ Net-_C2_43-Pad1_ IND_FH1812
XL2_42 Net-_C2_41-Pad1_ Net-_C2_42-Pad1_ IND_FH1812
C2_41 Net-_C2_41-Pad1_ GND 120p
XL2_40 Net-_C2_39-Pad1_ /line2/N40 IND_FH1812
CDTA2 +5VA GND 100n
C2_39 Net-_C2_39-Pad1_ GND 120p
XUTB2 /line2/N8 T2_1 T2_1 +5VA /line2/N24 T2_3 T2_3 /line2/N40 T2_5 T2_5 /line2/N56 T2_7 T2_7 GND OPA_QUAD
XL2_18 Net-_C2_17-Pad1_ Net-_C2_18-Pad1_ IND_FH1812
C2_17 Net-_C2_17-Pad1_ GND 120p
XL2_17 /line2/N16 Net-_C2_17-Pad1_ IND_FH1812
C2_16 /line2/N16 GND 120p
C2_15 Net-_C2_15-Pad1_ GND 120p
XL2_16 Net-_C2_15-Pad1_ /line2/N16 IND_FH1812
C2_19 Net-_C2_19-Pad1_ GND 120p
C2_18 Net-_C2_18-Pad1_ GND 120p
XL2_19 Net-_C2_18-Pad1_ Net-_C2_19-Pad1_ IND_FH1812
C2_28 /line2/N28 GND 120p
XL2_24 Net-_C2_23-Pad1_ /line2/N24 IND_FH1812
C2_26 Net-_C2_26-Pad1_ GND 120p
XL2_27 Net-_C2_26-Pad1_ Net-_C2_27-Pad1_ IND_FH1812
C2_27 Net-_C2_27-Pad1_ GND 120p
XL2_28 Net-_C2_27-Pad1_ /line2/N28 IND_FH1812
C2_24 /line2/N24 GND 120p
XL2_25 /line2/N24 Net-_C2_25-Pad1_ IND_FH1812
C2_25 Net-_C2_25-Pad1_ GND 120p
XL2_26 Net-_C2_25-Pad1_ Net-_C2_26-Pad1_ IND_FH1812
C2_53 Net-_C2_53-Pad1_ GND 120p
XL2_54 Net-_C2_53-Pad1_ Net-_C2_54-Pad1_ IND_FH1812
XL2_55 Net-_C2_54-Pad1_ Net-_C2_55-Pad1_ IND_FH1812
C2_54 Net-_C2_54-Pad1_ GND 120p
XL2_53 Net-_C2_52-Pad1_ Net-_C2_53-Pad1_ IND_FH1812
XL2_52 Net-_C2_51-Pad1_ Net-_C2_52-Pad1_ IND_FH1812
C2_52 Net-_C2_52-Pad1_ GND 120p
C2_55 Net-_C2_55-Pad1_ GND 120p
XL2_56 Net-_C2_55-Pad1_ /line2/N56 IND_FH1812
C2_56_1 /line2/N56 GND 30p
CDTB2 +5VA GND 100n
C2_56_2 /line2/N56 GND 30p
RT2 /line2/N56 GND 1k
XL2_47 Net-_C2_46-Pad1_ Net-_C2_47-Pad1_ IND_FH1812
C2_46 Net-_C2_46-Pad1_ GND 120p
C2_44 Net-_C2_44-Pad1_ GND 120p
C2_45 Net-_C2_45-Pad1_ GND 120p
XL2_46 Net-_C2_45-Pad1_ Net-_C2_46-Pad1_ IND_FH1812
XL2_45 Net-_C2_44-Pad1_ Net-_C2_45-Pad1_ IND_FH1812
C2_47 Net-_C2_47-Pad1_ GND 120p
XL2_44 Net-_C2_43-Pad1_ Net-_C2_44-Pad1_ IND_FH1812
C2_43 Net-_C2_43-Pad1_ GND 120p
CP3 /line3/RC GND 330p
RP3 SIG3 /line3/RC 1k
RS3 /line3/IB /line3/N0 1k
XL3_10 Net-_C3_9-Pad1_ Net-_C3_10-Pad1_ IND_FH1812
C3_9 Net-_C3_9-Pad1_ GND 120p
XL3_6 Net-_C3_5-Pad1_ Net-_C3_6-Pad1_ IND_FH1812
C3_6 Net-_C3_6-Pad1_ GND 120p
XL3_9 /line3/N8 Net-_C3_9-Pad1_ IND_FH1812
C3_8 /line3/N8 GND 120p
XL3_8 Net-_C3_7-Pad1_ /line3/N8 IND_FH1812
XL3_7 Net-_C3_6-Pad1_ Net-_C3_7-Pad1_ IND_FH1812
C3_7 Net-_C3_7-Pad1_ GND 120p
C3_10 Net-_C3_10-Pad1_ GND 120p
XL3_11 Net-_C3_10-Pad1_ Net-_C3_11-Pad1_ IND_FH1812
XL3_1 /line3/N0 Net-_C3_1-Pad1_ IND_FH1812
C3_1 Net-_C3_1-Pad1_ GND 120p
XL3_3 Net-_C3_2-Pad1_ Net-_C3_3-Pad1_ IND_FH1812
C3_3 Net-_C3_3-Pad1_ GND 120p
XL3_2 Net-_C3_1-Pad1_ Net-_C3_2-Pad1_ IND_FH1812
C3_2 Net-_C3_2-Pad1_ GND 120p
XL3_4 Net-_C3_3-Pad1_ Net-_C3_4-Pad1_ IND_FH1812
XL3_5 Net-_C3_4-Pad1_ Net-_C3_5-Pad1_ IND_FH1812
C3_4 Net-_C3_4-Pad1_ GND 120p
C3_5 Net-_C3_5-Pad1_ GND 120p
C3_0_1 /line3/N0 GND 30p
C3_0_2 /line3/N0 GND 30p
XL3_30 Net-_C3_29-Pad1_ Net-_C3_30-Pad1_ IND_FH1812
C3_29 Net-_C3_29-Pad1_ GND 120p
C3_31 Net-_C3_31-Pad1_ GND 120p
XL3_32 Net-_C3_31-Pad1_ /line3/N32 IND_FH1812
XL3_33 /line3/N32 Net-_C3_33-Pad1_ IND_FH1812
C3_32 /line3/N32 GND 120p
XL3_31 Net-_C3_30-Pad1_ Net-_C3_31-Pad1_ IND_FH1812
C3_30 Net-_C3_30-Pad1_ GND 120p
XL3_29 /line3/N28 Net-_C3_29-Pad1_ IND_FH1812
XL3_34 Net-_C3_33-Pad1_ Net-_C3_34-Pad1_ IND_FH1812
C3_34 Net-_C3_34-Pad1_ GND 120p
C3_36 Net-_C3_36-Pad1_ GND 120p
XL3_37 Net-_C3_36-Pad1_ Net-_C3_37-Pad1_ IND_FH1812
XL3_38 Net-_C3_37-Pad1_ Net-_C3_38-Pad1_ IND_FH1812
C3_37 Net-_C3_37-Pad1_ GND 120p
XL3_36 Net-_C3_35-Pad1_ Net-_C3_36-Pad1_ IND_FH1812
XL3_35 Net-_C3_34-Pad1_ Net-_C3_35-Pad1_ IND_FH1812
C3_35 Net-_C3_35-Pad1_ GND 120p
C3_38 Net-_C3_38-Pad1_ GND 120p
XUTA3 /line3/N0 T3_0 T3_0 +5VA /line3/N16 T3_2 T3_2 /line3/N32 T3_4 T3_4 /line3/N48 T3_6 T3_6 GND OPA_QUAD
XL3_39 Net-_C3_38-Pad1_ Net-_C3_39-Pad1_ IND_FH1812
C3_33 Net-_C3_33-Pad1_ GND 120p
C3_11 Net-_C3_11-Pad1_ GND 120p
C3_13 Net-_C3_13-Pad1_ GND 120p
XL3_14 Net-_C3_13-Pad1_ Net-_C3_14-Pad1_ IND_FH1812
C3_14 Net-_C3_14-Pad1_ GND 120p
XL3_15 Net-_C3_14-Pad1_ Net-_C3_15-Pad1_ IND_FH1812
XL3_13 Net-_C3_12-Pad1_ Net-_C3_13-Pad1_ IND_FH1812
XL3_12 Net-_C3_11-Pad1_ Net-_C3_12-Pad1_ IND_FH1812
C3_12 Net-_C3_12-Pad1_ GND 120p
XL3_22 Net-_C3_21-Pad1_ Net-_C3_22-Pad1_ IND_FH1812
C3_21 Net-_C3_21-Pad1_ GND 120p
XL3_48 Net-_C3_47-Pad1_ /line3/N48 IND_FH1812
C3_51 Net-_C3_51-Pad1_ GND 120p
XL3_51 Net-_C3_50-Pad1_ Net-_C3_51-Pad1_ IND_FH1812
C3_49 Net-_C3_49-Pad1_ GND 120p
XL3_23 Net-_C3_22-Pad1_ Net-_C3_23-Pad1_ IND_FH1812
C3_22 Net-_C3_22-Pad1_ GND 120p
C3_23 Net-_C3_23-Pad1_ GND 120p
C3_20 Net-_C3_20-Pad1_ GND 120p
XL3_21 Net-_C3_20-Pad1_ Net-_C3_21-Pad1_ IND_FH1812
XL3_20 Net-_C3_19-Pad1_ Net-_C3_20-Pad1_ IND_FH1812
XL3_49 /line3/N48 Net-_C3_49-Pad1_ IND_FH1812
C3_48 /line3/N48 GND 120p
XL3_50 Net-_C3_49-Pad1_ Net-_C3_50-Pad1_ IND_FH1812
C3_50 Net-_C3_50-Pad1_ GND 120p
XL3_41 /line3/N40 Net-_C3_41-Pad1_ IND_FH1812
C3_40 /line3/N40 GND 120p
C3_42 Net-_C3_42-Pad1_ GND 120p
XL3_43 Net-_C3_42-Pad1_ Net-_C3_43-Pad1_ IND_FH1812
XL3_42 Net-_C3_41-Pad1_ Net-_C3_42-Pad1_ IND_FH1812
C3_41 Net-_C3_41-Pad1_ GND 120p
XL3_40 Net-_C3_39-Pad1_ /line3/N40 IND_FH1812
CDTA3 +5VA GND 100n
C3_39 Net-_C3_39-Pad1_ GND 120p
XUTB3 /line3/N8 T3_1 T3_1 +5VA /line3/N24 T3_3 T3_3 /line3/N40 T3_5 T3_5 /line3/N56 T3_7 T3_7 GND OPA_QUAD
XL3_18 Net-_C3_17-Pad1_ Net-_C3_18-Pad1_ IND_FH1812
C3_17 Net-_C3_17-Pad1_ GND 120p
XL3_17 /line3/N16 Net-_C3_17-Pad1_ IND_FH1812
C3_16 /line3/N16 GND 120p
C3_15 Net-_C3_15-Pad1_ GND 120p
XL3_16 Net-_C3_15-Pad1_ /line3/N16 IND_FH1812
C3_19 Net-_C3_19-Pad1_ GND 120p
C3_18 Net-_C3_18-Pad1_ GND 120p
XL3_19 Net-_C3_18-Pad1_ Net-_C3_19-Pad1_ IND_FH1812
C3_28 /line3/N28 GND 120p
XL3_24 Net-_C3_23-Pad1_ /line3/N24 IND_FH1812
C3_26 Net-_C3_26-Pad1_ GND 120p
XL3_27 Net-_C3_26-Pad1_ Net-_C3_27-Pad1_ IND_FH1812
C3_27 Net-_C3_27-Pad1_ GND 120p
XL3_28 Net-_C3_27-Pad1_ /line3/N28 IND_FH1812
C3_24 /line3/N24 GND 120p
XL3_25 /line3/N24 Net-_C3_25-Pad1_ IND_FH1812
C3_25 Net-_C3_25-Pad1_ GND 120p
XL3_26 Net-_C3_25-Pad1_ Net-_C3_26-Pad1_ IND_FH1812
C3_53 Net-_C3_53-Pad1_ GND 120p
XL3_54 Net-_C3_53-Pad1_ Net-_C3_54-Pad1_ IND_FH1812
XL3_55 Net-_C3_54-Pad1_ Net-_C3_55-Pad1_ IND_FH1812
C3_54 Net-_C3_54-Pad1_ GND 120p
XL3_53 Net-_C3_52-Pad1_ Net-_C3_53-Pad1_ IND_FH1812
XL3_52 Net-_C3_51-Pad1_ Net-_C3_52-Pad1_ IND_FH1812
C3_52 Net-_C3_52-Pad1_ GND 120p
C3_55 Net-_C3_55-Pad1_ GND 120p
XL3_56 Net-_C3_55-Pad1_ /line3/N56 IND_FH1812
C3_56_1 /line3/N56 GND 30p
CDTB3 +5VA GND 100n
C3_56_2 /line3/N56 GND 30p
RT3 /line3/N56 GND 1k
XL3_47 Net-_C3_46-Pad1_ Net-_C3_47-Pad1_ IND_FH1812
C3_46 Net-_C3_46-Pad1_ GND 120p
C3_44 Net-_C3_44-Pad1_ GND 120p
C3_45 Net-_C3_45-Pad1_ GND 120p
XL3_46 Net-_C3_45-Pad1_ Net-_C3_46-Pad1_ IND_FH1812
XL3_45 Net-_C3_44-Pad1_ Net-_C3_45-Pad1_ IND_FH1812
C3_47 Net-_C3_47-Pad1_ GND 120p
XL3_44 Net-_C3_43-Pad1_ Net-_C3_44-Pad1_ IND_FH1812
C3_43 Net-_C3_43-Pad1_ GND 120p
CP4 /line4/RC GND 330p
RP4 SIG4 /line4/RC 1k
RS4 /line4/IB /line4/N0 1k
XL4_10 Net-_C4_9-Pad1_ Net-_C4_10-Pad1_ IND_FH1812
C4_9 Net-_C4_9-Pad1_ GND 120p
XL4_6 Net-_C4_5-Pad1_ Net-_C4_6-Pad1_ IND_FH1812
C4_6 Net-_C4_6-Pad1_ GND 120p
XL4_9 /line4/N8 Net-_C4_9-Pad1_ IND_FH1812
C4_8 /line4/N8 GND 120p
XL4_8 Net-_C4_7-Pad1_ /line4/N8 IND_FH1812
XL4_7 Net-_C4_6-Pad1_ Net-_C4_7-Pad1_ IND_FH1812
C4_7 Net-_C4_7-Pad1_ GND 120p
C4_10 Net-_C4_10-Pad1_ GND 120p
XL4_11 Net-_C4_10-Pad1_ Net-_C4_11-Pad1_ IND_FH1812
XL4_1 /line4/N0 Net-_C4_1-Pad1_ IND_FH1812
C4_1 Net-_C4_1-Pad1_ GND 120p
XL4_3 Net-_C4_2-Pad1_ Net-_C4_3-Pad1_ IND_FH1812
C4_3 Net-_C4_3-Pad1_ GND 120p
XL4_2 Net-_C4_1-Pad1_ Net-_C4_2-Pad1_ IND_FH1812
C4_2 Net-_C4_2-Pad1_ GND 120p
XL4_4 Net-_C4_3-Pad1_ Net-_C4_4-Pad1_ IND_FH1812
XL4_5 Net-_C4_4-Pad1_ Net-_C4_5-Pad1_ IND_FH1812
C4_4 Net-_C4_4-Pad1_ GND 120p
C4_5 Net-_C4_5-Pad1_ GND 120p
C4_0_1 /line4/N0 GND 30p
C4_0_2 /line4/N0 GND 30p
XL4_30 Net-_C4_29-Pad1_ Net-_C4_30-Pad1_ IND_FH1812
C4_29 Net-_C4_29-Pad1_ GND 120p
C4_31 Net-_C4_31-Pad1_ GND 120p
XL4_32 Net-_C4_31-Pad1_ /line4/N32 IND_FH1812
XL4_33 /line4/N32 Net-_C4_33-Pad1_ IND_FH1812
C4_32 /line4/N32 GND 120p
XL4_31 Net-_C4_30-Pad1_ Net-_C4_31-Pad1_ IND_FH1812
C4_30 Net-_C4_30-Pad1_ GND 120p
XL4_29 /line4/N28 Net-_C4_29-Pad1_ IND_FH1812
XL4_34 Net-_C4_33-Pad1_ Net-_C4_34-Pad1_ IND_FH1812
C4_34 Net-_C4_34-Pad1_ GND 120p
C4_36 Net-_C4_36-Pad1_ GND 120p
XL4_37 Net-_C4_36-Pad1_ Net-_C4_37-Pad1_ IND_FH1812
XL4_38 Net-_C4_37-Pad1_ Net-_C4_38-Pad1_ IND_FH1812
C4_37 Net-_C4_37-Pad1_ GND 120p
XL4_36 Net-_C4_35-Pad1_ Net-_C4_36-Pad1_ IND_FH1812
XL4_35 Net-_C4_34-Pad1_ Net-_C4_35-Pad1_ IND_FH1812
C4_35 Net-_C4_35-Pad1_ GND 120p
C4_38 Net-_C4_38-Pad1_ GND 120p
XUTA4 /line4/N0 T4_0 T4_0 +5VA /line4/N16 T4_2 T4_2 /line4/N32 T4_4 T4_4 /line4/N48 T4_6 T4_6 GND OPA_QUAD
XL4_39 Net-_C4_38-Pad1_ Net-_C4_39-Pad1_ IND_FH1812
C4_33 Net-_C4_33-Pad1_ GND 120p
C4_11 Net-_C4_11-Pad1_ GND 120p
C4_13 Net-_C4_13-Pad1_ GND 120p
XL4_14 Net-_C4_13-Pad1_ Net-_C4_14-Pad1_ IND_FH1812
C4_14 Net-_C4_14-Pad1_ GND 120p
XL4_15 Net-_C4_14-Pad1_ Net-_C4_15-Pad1_ IND_FH1812
XL4_13 Net-_C4_12-Pad1_ Net-_C4_13-Pad1_ IND_FH1812
XL4_12 Net-_C4_11-Pad1_ Net-_C4_12-Pad1_ IND_FH1812
C4_12 Net-_C4_12-Pad1_ GND 120p
XL4_22 Net-_C4_21-Pad1_ Net-_C4_22-Pad1_ IND_FH1812
C4_21 Net-_C4_21-Pad1_ GND 120p
XL4_48 Net-_C4_47-Pad1_ /line4/N48 IND_FH1812
C4_51 Net-_C4_51-Pad1_ GND 120p
XL4_51 Net-_C4_50-Pad1_ Net-_C4_51-Pad1_ IND_FH1812
C4_49 Net-_C4_49-Pad1_ GND 120p
XL4_23 Net-_C4_22-Pad1_ Net-_C4_23-Pad1_ IND_FH1812
C4_22 Net-_C4_22-Pad1_ GND 120p
C4_23 Net-_C4_23-Pad1_ GND 120p
C4_20 Net-_C4_20-Pad1_ GND 120p
XL4_21 Net-_C4_20-Pad1_ Net-_C4_21-Pad1_ IND_FH1812
XL4_20 Net-_C4_19-Pad1_ Net-_C4_20-Pad1_ IND_FH1812
XL4_49 /line4/N48 Net-_C4_49-Pad1_ IND_FH1812
C4_48 /line4/N48 GND 120p
XL4_50 Net-_C4_49-Pad1_ Net-_C4_50-Pad1_ IND_FH1812
C4_50 Net-_C4_50-Pad1_ GND 120p
XL4_41 /line4/N40 Net-_C4_41-Pad1_ IND_FH1812
C4_40 /line4/N40 GND 120p
C4_42 Net-_C4_42-Pad1_ GND 120p
XL4_43 Net-_C4_42-Pad1_ Net-_C4_43-Pad1_ IND_FH1812
XL4_42 Net-_C4_41-Pad1_ Net-_C4_42-Pad1_ IND_FH1812
C4_41 Net-_C4_41-Pad1_ GND 120p
XL4_40 Net-_C4_39-Pad1_ /line4/N40 IND_FH1812
CDTA4 +5VA GND 100n
C4_39 Net-_C4_39-Pad1_ GND 120p
XUTB4 /line4/N8 T4_1 T4_1 +5VA /line4/N24 T4_3 T4_3 /line4/N40 T4_5 T4_5 /line4/N56 T4_7 T4_7 GND OPA_QUAD
XL4_18 Net-_C4_17-Pad1_ Net-_C4_18-Pad1_ IND_FH1812
C4_17 Net-_C4_17-Pad1_ GND 120p
XL4_17 /line4/N16 Net-_C4_17-Pad1_ IND_FH1812
C4_16 /line4/N16 GND 120p
C4_15 Net-_C4_15-Pad1_ GND 120p
XL4_16 Net-_C4_15-Pad1_ /line4/N16 IND_FH1812
C4_19 Net-_C4_19-Pad1_ GND 120p
C4_18 Net-_C4_18-Pad1_ GND 120p
XL4_19 Net-_C4_18-Pad1_ Net-_C4_19-Pad1_ IND_FH1812
C4_28 /line4/N28 GND 120p
XL4_24 Net-_C4_23-Pad1_ /line4/N24 IND_FH1812
C4_26 Net-_C4_26-Pad1_ GND 120p
XL4_27 Net-_C4_26-Pad1_ Net-_C4_27-Pad1_ IND_FH1812
C4_27 Net-_C4_27-Pad1_ GND 120p
XL4_28 Net-_C4_27-Pad1_ /line4/N28 IND_FH1812
C4_24 /line4/N24 GND 120p
XL4_25 /line4/N24 Net-_C4_25-Pad1_ IND_FH1812
C4_25 Net-_C4_25-Pad1_ GND 120p
XL4_26 Net-_C4_25-Pad1_ Net-_C4_26-Pad1_ IND_FH1812
C4_53 Net-_C4_53-Pad1_ GND 120p
XL4_54 Net-_C4_53-Pad1_ Net-_C4_54-Pad1_ IND_FH1812
XL4_55 Net-_C4_54-Pad1_ Net-_C4_55-Pad1_ IND_FH1812
C4_54 Net-_C4_54-Pad1_ GND 120p
XL4_53 Net-_C4_52-Pad1_ Net-_C4_53-Pad1_ IND_FH1812
XL4_52 Net-_C4_51-Pad1_ Net-_C4_52-Pad1_ IND_FH1812
C4_52 Net-_C4_52-Pad1_ GND 120p
C4_55 Net-_C4_55-Pad1_ GND 120p
XL4_56 Net-_C4_55-Pad1_ /line4/N56 IND_FH1812
C4_56_1 /line4/N56 GND 30p
CDTB4 +5VA GND 100n
C4_56_2 /line4/N56 GND 30p
RT4 /line4/N56 GND 1k
XL4_47 Net-_C4_46-Pad1_ Net-_C4_47-Pad1_ IND_FH1812
C4_46 Net-_C4_46-Pad1_ GND 120p
C4_44 Net-_C4_44-Pad1_ GND 120p
C4_45 Net-_C4_45-Pad1_ GND 120p
XL4_46 Net-_C4_45-Pad1_ Net-_C4_46-Pad1_ IND_FH1812
XL4_45 Net-_C4_44-Pad1_ Net-_C4_45-Pad1_ IND_FH1812
C4_47 Net-_C4_47-Pad1_ GND 120p
XL4_44 Net-_C4_43-Pad1_ Net-_C4_44-Pad1_ IND_FH1812
C4_43 Net-_C4_43-Pad1_ GND 120p
CP5 /line5/RC GND 330p
RP5 SIG5 /line5/RC 1k
RS5 /line5/IB /line5/N0 1k
XL5_10 Net-_C5_9-Pad1_ Net-_C5_10-Pad1_ IND_FH1812
C5_9 Net-_C5_9-Pad1_ GND 120p
XL5_6 Net-_C5_5-Pad1_ Net-_C5_6-Pad1_ IND_FH1812
C5_6 Net-_C5_6-Pad1_ GND 120p
XL5_9 /line5/N8 Net-_C5_9-Pad1_ IND_FH1812
C5_8 /line5/N8 GND 120p
XL5_8 Net-_C5_7-Pad1_ /line5/N8 IND_FH1812
XL5_7 Net-_C5_6-Pad1_ Net-_C5_7-Pad1_ IND_FH1812
C5_7 Net-_C5_7-Pad1_ GND 120p
C5_10 Net-_C5_10-Pad1_ GND 120p
XL5_11 Net-_C5_10-Pad1_ Net-_C5_11-Pad1_ IND_FH1812
XL5_1 /line5/N0 Net-_C5_1-Pad1_ IND_FH1812
C5_1 Net-_C5_1-Pad1_ GND 120p
XL5_3 Net-_C5_2-Pad1_ Net-_C5_3-Pad1_ IND_FH1812
C5_3 Net-_C5_3-Pad1_ GND 120p
XL5_2 Net-_C5_1-Pad1_ Net-_C5_2-Pad1_ IND_FH1812
C5_2 Net-_C5_2-Pad1_ GND 120p
XL5_4 Net-_C5_3-Pad1_ Net-_C5_4-Pad1_ IND_FH1812
XL5_5 Net-_C5_4-Pad1_ Net-_C5_5-Pad1_ IND_FH1812
C5_4 Net-_C5_4-Pad1_ GND 120p
C5_5 Net-_C5_5-Pad1_ GND 120p
C5_0_1 /line5/N0 GND 30p
C5_0_2 /line5/N0 GND 30p
XL5_30 Net-_C5_29-Pad1_ Net-_C5_30-Pad1_ IND_FH1812
C5_29 Net-_C5_29-Pad1_ GND 120p
C5_31 Net-_C5_31-Pad1_ GND 120p
XL5_32 Net-_C5_31-Pad1_ /line5/N32 IND_FH1812
XL5_33 /line5/N32 Net-_C5_33-Pad1_ IND_FH1812
C5_32 /line5/N32 GND 120p
XL5_31 Net-_C5_30-Pad1_ Net-_C5_31-Pad1_ IND_FH1812
C5_30 Net-_C5_30-Pad1_ GND 120p
XL5_29 /line5/N28 Net-_C5_29-Pad1_ IND_FH1812
XL5_34 Net-_C5_33-Pad1_ Net-_C5_34-Pad1_ IND_FH1812
C5_34 Net-_C5_34-Pad1_ GND 120p
C5_36 Net-_C5_36-Pad1_ GND 120p
XL5_37 Net-_C5_36-Pad1_ Net-_C5_37-Pad1_ IND_FH1812
XL5_38 Net-_C5_37-Pad1_ Net-_C5_38-Pad1_ IND_FH1812
C5_37 Net-_C5_37-Pad1_ GND 120p
XL5_36 Net-_C5_35-Pad1_ Net-_C5_36-Pad1_ IND_FH1812
XL5_35 Net-_C5_34-Pad1_ Net-_C5_35-Pad1_ IND_FH1812
C5_35 Net-_C5_35-Pad1_ GND 120p
C5_38 Net-_C5_38-Pad1_ GND 120p
XUTA5 /line5/N0 T5_0 T5_0 +5VA /line5/N16 T5_2 T5_2 /line5/N32 T5_4 T5_4 /line5/N48 T5_6 T5_6 GND OPA_QUAD
XL5_39 Net-_C5_38-Pad1_ Net-_C5_39-Pad1_ IND_FH1812
C5_33 Net-_C5_33-Pad1_ GND 120p
C5_11 Net-_C5_11-Pad1_ GND 120p
C5_13 Net-_C5_13-Pad1_ GND 120p
XL5_14 Net-_C5_13-Pad1_ Net-_C5_14-Pad1_ IND_FH1812
C5_14 Net-_C5_14-Pad1_ GND 120p
XL5_15 Net-_C5_14-Pad1_ Net-_C5_15-Pad1_ IND_FH1812
XL5_13 Net-_C5_12-Pad1_ Net-_C5_13-Pad1_ IND_FH1812
XL5_12 Net-_C5_11-Pad1_ Net-_C5_12-Pad1_ IND_FH1812
C5_12 Net-_C5_12-Pad1_ GND 120p
XL5_22 Net-_C5_21-Pad1_ Net-_C5_22-Pad1_ IND_FH1812
C5_21 Net-_C5_21-Pad1_ GND 120p
XL5_48 Net-_C5_47-Pad1_ /line5/N48 IND_FH1812
C5_51 Net-_C5_51-Pad1_ GND 120p
XL5_51 Net-_C5_50-Pad1_ Net-_C5_51-Pad1_ IND_FH1812
C5_49 Net-_C5_49-Pad1_ GND 120p
XL5_23 Net-_C5_22-Pad1_ Net-_C5_23-Pad1_ IND_FH1812
C5_22 Net-_C5_22-Pad1_ GND 120p
C5_23 Net-_C5_23-Pad1_ GND 120p
C5_20 Net-_C5_20-Pad1_ GND 120p
XL5_21 Net-_C5_20-Pad1_ Net-_C5_21-Pad1_ IND_FH1812
XL5_20 Net-_C5_19-Pad1_ Net-_C5_20-Pad1_ IND_FH1812
XL5_49 /line5/N48 Net-_C5_49-Pad1_ IND_FH1812
C5_48 /line5/N48 GND 120p
XL5_50 Net-_C5_49-Pad1_ Net-_C5_50-Pad1_ IND_FH1812
C5_50 Net-_C5_50-Pad1_ GND 120p
XL5_41 /line5/N40 Net-_C5_41-Pad1_ IND_FH1812
C5_40 /line5/N40 GND 120p
C5_42 Net-_C5_42-Pad1_ GND 120p
XL5_43 Net-_C5_42-Pad1_ Net-_C5_43-Pad1_ IND_FH1812
XL5_42 Net-_C5_41-Pad1_ Net-_C5_42-Pad1_ IND_FH1812
C5_41 Net-_C5_41-Pad1_ GND 120p
XL5_40 Net-_C5_39-Pad1_ /line5/N40 IND_FH1812
CDTA5 +5VA GND 100n
C5_39 Net-_C5_39-Pad1_ GND 120p
XUTB5 /line5/N8 T5_1 T5_1 +5VA /line5/N24 T5_3 T5_3 /line5/N40 T5_5 T5_5 /line5/N56 T5_7 T5_7 GND OPA_QUAD
XL5_18 Net-_C5_17-Pad1_ Net-_C5_18-Pad1_ IND_FH1812
C5_17 Net-_C5_17-Pad1_ GND 120p
XL5_17 /line5/N16 Net-_C5_17-Pad1_ IND_FH1812
C5_16 /line5/N16 GND 120p
C5_15 Net-_C5_15-Pad1_ GND 120p
XL5_16 Net-_C5_15-Pad1_ /line5/N16 IND_FH1812
C5_19 Net-_C5_19-Pad1_ GND 120p
C5_18 Net-_C5_18-Pad1_ GND 120p
XL5_19 Net-_C5_18-Pad1_ Net-_C5_19-Pad1_ IND_FH1812
C5_28 /line5/N28 GND 120p
XL5_24 Net-_C5_23-Pad1_ /line5/N24 IND_FH1812
C5_26 Net-_C5_26-Pad1_ GND 120p
XL5_27 Net-_C5_26-Pad1_ Net-_C5_27-Pad1_ IND_FH1812
C5_27 Net-_C5_27-Pad1_ GND 120p
XL5_28 Net-_C5_27-Pad1_ /line5/N28 IND_FH1812
C5_24 /line5/N24 GND 120p
XL5_25 /line5/N24 Net-_C5_25-Pad1_ IND_FH1812
C5_25 Net-_C5_25-Pad1_ GND 120p
XL5_26 Net-_C5_25-Pad1_ Net-_C5_26-Pad1_ IND_FH1812
C5_53 Net-_C5_53-Pad1_ GND 120p
XL5_54 Net-_C5_53-Pad1_ Net-_C5_54-Pad1_ IND_FH1812
XL5_55 Net-_C5_54-Pad1_ Net-_C5_55-Pad1_ IND_FH1812
C5_54 Net-_C5_54-Pad1_ GND 120p
XL5_53 Net-_C5_52-Pad1_ Net-_C5_53-Pad1_ IND_FH1812
XL5_52 Net-_C5_51-Pad1_ Net-_C5_52-Pad1_ IND_FH1812
C5_52 Net-_C5_52-Pad1_ GND 120p
C5_55 Net-_C5_55-Pad1_ GND 120p
XL5_56 Net-_C5_55-Pad1_ /line5/N56 IND_FH1812
C5_56_1 /line5/N56 GND 30p
CDTB5 +5VA GND 100n
C5_56_2 /line5/N56 GND 30p
RT5 /line5/N56 GND 1k
XL5_47 Net-_C5_46-Pad1_ Net-_C5_47-Pad1_ IND_FH1812
C5_46 Net-_C5_46-Pad1_ GND 120p
C5_44 Net-_C5_44-Pad1_ GND 120p
C5_45 Net-_C5_45-Pad1_ GND 120p
XL5_46 Net-_C5_45-Pad1_ Net-_C5_46-Pad1_ IND_FH1812
XL5_45 Net-_C5_44-Pad1_ Net-_C5_45-Pad1_ IND_FH1812
C5_47 Net-_C5_47-Pad1_ GND 120p
XL5_44 Net-_C5_43-Pad1_ Net-_C5_44-Pad1_ IND_FH1812
C5_43 Net-_C5_43-Pad1_ GND 120p
CP6 /line6/RC GND 330p
RP6 SIG6 /line6/RC 1k
RS6 /line6/IB /line6/N0 1k
XL6_10 Net-_C6_9-Pad1_ Net-_C6_10-Pad1_ IND_FH1812
C6_9 Net-_C6_9-Pad1_ GND 120p
XL6_6 Net-_C6_5-Pad1_ Net-_C6_6-Pad1_ IND_FH1812
C6_6 Net-_C6_6-Pad1_ GND 120p
XL6_9 /line6/N8 Net-_C6_9-Pad1_ IND_FH1812
C6_8 /line6/N8 GND 120p
XL6_8 Net-_C6_7-Pad1_ /line6/N8 IND_FH1812
XL6_7 Net-_C6_6-Pad1_ Net-_C6_7-Pad1_ IND_FH1812
C6_7 Net-_C6_7-Pad1_ GND 120p
C6_10 Net-_C6_10-Pad1_ GND 120p
XL6_11 Net-_C6_10-Pad1_ Net-_C6_11-Pad1_ IND_FH1812
XL6_1 /line6/N0 Net-_C6_1-Pad1_ IND_FH1812
C6_1 Net-_C6_1-Pad1_ GND 120p
XL6_3 Net-_C6_2-Pad1_ Net-_C6_3-Pad1_ IND_FH1812
C6_3 Net-_C6_3-Pad1_ GND 120p
XL6_2 Net-_C6_1-Pad1_ Net-_C6_2-Pad1_ IND_FH1812
C6_2 Net-_C6_2-Pad1_ GND 120p
XL6_4 Net-_C6_3-Pad1_ Net-_C6_4-Pad1_ IND_FH1812
XL6_5 Net-_C6_4-Pad1_ Net-_C6_5-Pad1_ IND_FH1812
C6_4 Net-_C6_4-Pad1_ GND 120p
C6_5 Net-_C6_5-Pad1_ GND 120p
C6_0_1 /line6/N0 GND 30p
C6_0_2 /line6/N0 GND 30p
XL6_30 Net-_C6_29-Pad1_ Net-_C6_30-Pad1_ IND_FH1812
C6_29 Net-_C6_29-Pad1_ GND 120p
C6_31 Net-_C6_31-Pad1_ GND 120p
XL6_32 Net-_C6_31-Pad1_ /line6/N32 IND_FH1812
XL6_33 /line6/N32 Net-_C6_33-Pad1_ IND_FH1812
C6_32 /line6/N32 GND 120p
XL6_31 Net-_C6_30-Pad1_ Net-_C6_31-Pad1_ IND_FH1812
C6_30 Net-_C6_30-Pad1_ GND 120p
XL6_29 /line6/N28 Net-_C6_29-Pad1_ IND_FH1812
XL6_34 Net-_C6_33-Pad1_ Net-_C6_34-Pad1_ IND_FH1812
C6_34 Net-_C6_34-Pad1_ GND 120p
C6_36 Net-_C6_36-Pad1_ GND 120p
XL6_37 Net-_C6_36-Pad1_ Net-_C6_37-Pad1_ IND_FH1812
XL6_38 Net-_C6_37-Pad1_ Net-_C6_38-Pad1_ IND_FH1812
C6_37 Net-_C6_37-Pad1_ GND 120p
XL6_36 Net-_C6_35-Pad1_ Net-_C6_36-Pad1_ IND_FH1812
XL6_35 Net-_C6_34-Pad1_ Net-_C6_35-Pad1_ IND_FH1812
C6_35 Net-_C6_35-Pad1_ GND 120p
C6_38 Net-_C6_38-Pad1_ GND 120p
XUTA6 /line6/N0 T6_0 T6_0 +5VA /line6/N16 T6_2 T6_2 /line6/N32 T6_4 T6_4 /line6/N48 T6_6 T6_6 GND OPA_QUAD
XL6_39 Net-_C6_38-Pad1_ Net-_C6_39-Pad1_ IND_FH1812
C6_33 Net-_C6_33-Pad1_ GND 120p
C6_11 Net-_C6_11-Pad1_ GND 120p
C6_13 Net-_C6_13-Pad1_ GND 120p
XL6_14 Net-_C6_13-Pad1_ Net-_C6_14-Pad1_ IND_FH1812
C6_14 Net-_C6_14-Pad1_ GND 120p
XL6_15 Net-_C6_14-Pad1_ Net-_C6_15-Pad1_ IND_FH1812
XL6_13 Net-_C6_12-Pad1_ Net-_C6_13-Pad1_ IND_FH1812
XL6_12 Net-_C6_11-Pad1_ Net-_C6_12-Pad1_ IND_FH1812
C6_12 Net-_C6_12-Pad1_ GND 120p
XL6_22 Net-_C6_21-Pad1_ Net-_C6_22-Pad1_ IND_FH1812
C6_21 Net-_C6_21-Pad1_ GND 120p
XL6_48 Net-_C6_47-Pad1_ /line6/N48 IND_FH1812
C6_51 Net-_C6_51-Pad1_ GND 120p
XL6_51 Net-_C6_50-Pad1_ Net-_C6_51-Pad1_ IND_FH1812
C6_49 Net-_C6_49-Pad1_ GND 120p
XL6_23 Net-_C6_22-Pad1_ Net-_C6_23-Pad1_ IND_FH1812
C6_22 Net-_C6_22-Pad1_ GND 120p
C6_23 Net-_C6_23-Pad1_ GND 120p
C6_20 Net-_C6_20-Pad1_ GND 120p
XL6_21 Net-_C6_20-Pad1_ Net-_C6_21-Pad1_ IND_FH1812
XL6_20 Net-_C6_19-Pad1_ Net-_C6_20-Pad1_ IND_FH1812
XL6_49 /line6/N48 Net-_C6_49-Pad1_ IND_FH1812
C6_48 /line6/N48 GND 120p
XL6_50 Net-_C6_49-Pad1_ Net-_C6_50-Pad1_ IND_FH1812
C6_50 Net-_C6_50-Pad1_ GND 120p
XL6_41 /line6/N40 Net-_C6_41-Pad1_ IND_FH1812
C6_40 /line6/N40 GND 120p
C6_42 Net-_C6_42-Pad1_ GND 120p
XL6_43 Net-_C6_42-Pad1_ Net-_C6_43-Pad1_ IND_FH1812
XL6_42 Net-_C6_41-Pad1_ Net-_C6_42-Pad1_ IND_FH1812
C6_41 Net-_C6_41-Pad1_ GND 120p
XL6_40 Net-_C6_39-Pad1_ /line6/N40 IND_FH1812
CDTA6 +5VA GND 100n
C6_39 Net-_C6_39-Pad1_ GND 120p
XUTB6 /line6/N8 T6_1 T6_1 +5VA /line6/N24 T6_3 T6_3 /line6/N40 T6_5 T6_5 /line6/N56 T6_7 T6_7 GND OPA_QUAD
XL6_18 Net-_C6_17-Pad1_ Net-_C6_18-Pad1_ IND_FH1812
C6_17 Net-_C6_17-Pad1_ GND 120p
XL6_17 /line6/N16 Net-_C6_17-Pad1_ IND_FH1812
C6_16 /line6/N16 GND 120p
C6_15 Net-_C6_15-Pad1_ GND 120p
XL6_16 Net-_C6_15-Pad1_ /line6/N16 IND_FH1812
C6_19 Net-_C6_19-Pad1_ GND 120p
C6_18 Net-_C6_18-Pad1_ GND 120p
XL6_19 Net-_C6_18-Pad1_ Net-_C6_19-Pad1_ IND_FH1812
C6_28 /line6/N28 GND 120p
XL6_24 Net-_C6_23-Pad1_ /line6/N24 IND_FH1812
C6_26 Net-_C6_26-Pad1_ GND 120p
XL6_27 Net-_C6_26-Pad1_ Net-_C6_27-Pad1_ IND_FH1812
C6_27 Net-_C6_27-Pad1_ GND 120p
XL6_28 Net-_C6_27-Pad1_ /line6/N28 IND_FH1812
C6_24 /line6/N24 GND 120p
XL6_25 /line6/N24 Net-_C6_25-Pad1_ IND_FH1812
C6_25 Net-_C6_25-Pad1_ GND 120p
XL6_26 Net-_C6_25-Pad1_ Net-_C6_26-Pad1_ IND_FH1812
C6_53 Net-_C6_53-Pad1_ GND 120p
XL6_54 Net-_C6_53-Pad1_ Net-_C6_54-Pad1_ IND_FH1812
XL6_55 Net-_C6_54-Pad1_ Net-_C6_55-Pad1_ IND_FH1812
C6_54 Net-_C6_54-Pad1_ GND 120p
XL6_53 Net-_C6_52-Pad1_ Net-_C6_53-Pad1_ IND_FH1812
XL6_52 Net-_C6_51-Pad1_ Net-_C6_52-Pad1_ IND_FH1812
C6_52 Net-_C6_52-Pad1_ GND 120p
C6_55 Net-_C6_55-Pad1_ GND 120p
XL6_56 Net-_C6_55-Pad1_ /line6/N56 IND_FH1812
C6_56_1 /line6/N56 GND 30p
CDTB6 +5VA GND 100n
C6_56_2 /line6/N56 GND 30p
RT6 /line6/N56 GND 1k
XL6_47 Net-_C6_46-Pad1_ Net-_C6_47-Pad1_ IND_FH1812
C6_46 Net-_C6_46-Pad1_ GND 120p
C6_44 Net-_C6_44-Pad1_ GND 120p
C6_45 Net-_C6_45-Pad1_ GND 120p
XL6_46 Net-_C6_45-Pad1_ Net-_C6_46-Pad1_ IND_FH1812
XL6_45 Net-_C6_44-Pad1_ Net-_C6_45-Pad1_ IND_FH1812
C6_47 Net-_C6_47-Pad1_ GND 120p
XL6_44 Net-_C6_43-Pad1_ Net-_C6_44-Pad1_ IND_FH1812
C6_43 Net-_C6_43-Pad1_ GND 120p
CP7 /line7/RC GND 330p
RP7 SIG7 /line7/RC 1k
RS7 /line7/IB /line7/N0 1k
XL7_10 Net-_C7_9-Pad1_ Net-_C7_10-Pad1_ IND_FH1812
C7_9 Net-_C7_9-Pad1_ GND 120p
XL7_6 Net-_C7_5-Pad1_ Net-_C7_6-Pad1_ IND_FH1812
C7_6 Net-_C7_6-Pad1_ GND 120p
XL7_9 /line7/N8 Net-_C7_9-Pad1_ IND_FH1812
C7_8 /line7/N8 GND 120p
XL7_8 Net-_C7_7-Pad1_ /line7/N8 IND_FH1812
XL7_7 Net-_C7_6-Pad1_ Net-_C7_7-Pad1_ IND_FH1812
C7_7 Net-_C7_7-Pad1_ GND 120p
C7_10 Net-_C7_10-Pad1_ GND 120p
XL7_11 Net-_C7_10-Pad1_ Net-_C7_11-Pad1_ IND_FH1812
XL7_1 /line7/N0 Net-_C7_1-Pad1_ IND_FH1812
C7_1 Net-_C7_1-Pad1_ GND 120p
XL7_3 Net-_C7_2-Pad1_ Net-_C7_3-Pad1_ IND_FH1812
C7_3 Net-_C7_3-Pad1_ GND 120p
XL7_2 Net-_C7_1-Pad1_ Net-_C7_2-Pad1_ IND_FH1812
C7_2 Net-_C7_2-Pad1_ GND 120p
XL7_4 Net-_C7_3-Pad1_ Net-_C7_4-Pad1_ IND_FH1812
XL7_5 Net-_C7_4-Pad1_ Net-_C7_5-Pad1_ IND_FH1812
C7_4 Net-_C7_4-Pad1_ GND 120p
C7_5 Net-_C7_5-Pad1_ GND 120p
C7_0_1 /line7/N0 GND 30p
C7_0_2 /line7/N0 GND 30p
XL7_30 Net-_C7_29-Pad1_ Net-_C7_30-Pad1_ IND_FH1812
C7_29 Net-_C7_29-Pad1_ GND 120p
C7_31 Net-_C7_31-Pad1_ GND 120p
XL7_32 Net-_C7_31-Pad1_ /line7/N32 IND_FH1812
XL7_33 /line7/N32 Net-_C7_33-Pad1_ IND_FH1812
C7_32 /line7/N32 GND 120p
XL7_31 Net-_C7_30-Pad1_ Net-_C7_31-Pad1_ IND_FH1812
C7_30 Net-_C7_30-Pad1_ GND 120p
XL7_29 /line7/N28 Net-_C7_29-Pad1_ IND_FH1812
XL7_34 Net-_C7_33-Pad1_ Net-_C7_34-Pad1_ IND_FH1812
C7_34 Net-_C7_34-Pad1_ GND 120p
C7_36 Net-_C7_36-Pad1_ GND 120p
XL7_37 Net-_C7_36-Pad1_ Net-_C7_37-Pad1_ IND_FH1812
XL7_38 Net-_C7_37-Pad1_ Net-_C7_38-Pad1_ IND_FH1812
C7_37 Net-_C7_37-Pad1_ GND 120p
XL7_36 Net-_C7_35-Pad1_ Net-_C7_36-Pad1_ IND_FH1812
XL7_35 Net-_C7_34-Pad1_ Net-_C7_35-Pad1_ IND_FH1812
C7_35 Net-_C7_35-Pad1_ GND 120p
C7_38 Net-_C7_38-Pad1_ GND 120p
XUTA7 /line7/N0 T7_0 T7_0 +5VA /line7/N16 T7_2 T7_2 /line7/N32 T7_4 T7_4 /line7/N48 T7_6 T7_6 GND OPA_QUAD
XL7_39 Net-_C7_38-Pad1_ Net-_C7_39-Pad1_ IND_FH1812
C7_33 Net-_C7_33-Pad1_ GND 120p
C7_11 Net-_C7_11-Pad1_ GND 120p
C7_13 Net-_C7_13-Pad1_ GND 120p
XL7_14 Net-_C7_13-Pad1_ Net-_C7_14-Pad1_ IND_FH1812
C7_14 Net-_C7_14-Pad1_ GND 120p
XL7_15 Net-_C7_14-Pad1_ Net-_C7_15-Pad1_ IND_FH1812
XL7_13 Net-_C7_12-Pad1_ Net-_C7_13-Pad1_ IND_FH1812
XL7_12 Net-_C7_11-Pad1_ Net-_C7_12-Pad1_ IND_FH1812
C7_12 Net-_C7_12-Pad1_ GND 120p
XL7_22 Net-_C7_21-Pad1_ Net-_C7_22-Pad1_ IND_FH1812
C7_21 Net-_C7_21-Pad1_ GND 120p
XL7_48 Net-_C7_47-Pad1_ /line7/N48 IND_FH1812
C7_51 Net-_C7_51-Pad1_ GND 120p
XL7_51 Net-_C7_50-Pad1_ Net-_C7_51-Pad1_ IND_FH1812
C7_49 Net-_C7_49-Pad1_ GND 120p
XL7_23 Net-_C7_22-Pad1_ Net-_C7_23-Pad1_ IND_FH1812
C7_22 Net-_C7_22-Pad1_ GND 120p
C7_23 Net-_C7_23-Pad1_ GND 120p
C7_20 Net-_C7_20-Pad1_ GND 120p
XL7_21 Net-_C7_20-Pad1_ Net-_C7_21-Pad1_ IND_FH1812
XL7_20 Net-_C7_19-Pad1_ Net-_C7_20-Pad1_ IND_FH1812
XL7_49 /line7/N48 Net-_C7_49-Pad1_ IND_FH1812
C7_48 /line7/N48 GND 120p
XL7_50 Net-_C7_49-Pad1_ Net-_C7_50-Pad1_ IND_FH1812
C7_50 Net-_C7_50-Pad1_ GND 120p
XL7_41 /line7/N40 Net-_C7_41-Pad1_ IND_FH1812
C7_40 /line7/N40 GND 120p
C7_42 Net-_C7_42-Pad1_ GND 120p
XL7_43 Net-_C7_42-Pad1_ Net-_C7_43-Pad1_ IND_FH1812
XL7_42 Net-_C7_41-Pad1_ Net-_C7_42-Pad1_ IND_FH1812
C7_41 Net-_C7_41-Pad1_ GND 120p
XL7_40 Net-_C7_39-Pad1_ /line7/N40 IND_FH1812
CDTA7 +5VA GND 100n
C7_39 Net-_C7_39-Pad1_ GND 120p
XUTB7 /line7/N8 T7_1 T7_1 +5VA /line7/N24 T7_3 T7_3 /line7/N40 T7_5 T7_5 /line7/N56 T7_7 T7_7 GND OPA_QUAD
XL7_18 Net-_C7_17-Pad1_ Net-_C7_18-Pad1_ IND_FH1812
C7_17 Net-_C7_17-Pad1_ GND 120p
XL7_17 /line7/N16 Net-_C7_17-Pad1_ IND_FH1812
C7_16 /line7/N16 GND 120p
C7_15 Net-_C7_15-Pad1_ GND 120p
XL7_16 Net-_C7_15-Pad1_ /line7/N16 IND_FH1812
C7_19 Net-_C7_19-Pad1_ GND 120p
C7_18 Net-_C7_18-Pad1_ GND 120p
XL7_19 Net-_C7_18-Pad1_ Net-_C7_19-Pad1_ IND_FH1812
C7_28 /line7/N28 GND 120p
XL7_24 Net-_C7_23-Pad1_ /line7/N24 IND_FH1812
C7_26 Net-_C7_26-Pad1_ GND 120p
XL7_27 Net-_C7_26-Pad1_ Net-_C7_27-Pad1_ IND_FH1812
C7_27 Net-_C7_27-Pad1_ GND 120p
XL7_28 Net-_C7_27-Pad1_ /line7/N28 IND_FH1812
C7_24 /line7/N24 GND 120p
XL7_25 /line7/N24 Net-_C7_25-Pad1_ IND_FH1812
C7_25 Net-_C7_25-Pad1_ GND 120p
XL7_26 Net-_C7_25-Pad1_ Net-_C7_26-Pad1_ IND_FH1812
C7_53 Net-_C7_53-Pad1_ GND 120p
XL7_54 Net-_C7_53-Pad1_ Net-_C7_54-Pad1_ IND_FH1812
XL7_55 Net-_C7_54-Pad1_ Net-_C7_55-Pad1_ IND_FH1812
C7_54 Net-_C7_54-Pad1_ GND 120p
XL7_53 Net-_C7_52-Pad1_ Net-_C7_53-Pad1_ IND_FH1812
XL7_52 Net-_C7_51-Pad1_ Net-_C7_52-Pad1_ IND_FH1812
C7_52 Net-_C7_52-Pad1_ GND 120p
C7_55 Net-_C7_55-Pad1_ GND 120p
XL7_56 Net-_C7_55-Pad1_ /line7/N56 IND_FH1812
C7_56_1 /line7/N56 GND 30p
CDTB7 +5VA GND 100n
C7_56_2 /line7/N56 GND 30p
RT7 /line7/N56 GND 1k
XL7_47 Net-_C7_46-Pad1_ Net-_C7_47-Pad1_ IND_FH1812
C7_46 Net-_C7_46-Pad1_ GND 120p
C7_44 Net-_C7_44-Pad1_ GND 120p
C7_45 Net-_C7_45-Pad1_ GND 120p
XL7_46 Net-_C7_45-Pad1_ Net-_C7_46-Pad1_ IND_FH1812
XL7_45 Net-_C7_44-Pad1_ Net-_C7_45-Pad1_ IND_FH1812
C7_47 Net-_C7_47-Pad1_ GND 120p
XL7_44 Net-_C7_43-Pad1_ Net-_C7_44-Pad1_ IND_FH1812
C7_43 Net-_C7_43-Pad1_ GND 120p
RXN_2_2_4 T2_4 SP2 10k
RXN_2_2_5 T2_5 SP2 10k
RXN_2_3_7 T3_7 SP2 10k
RXN_2_3_4 T3_4 SP2 10k
RXP_3_2_6 T2_6 SN3 10k
RXP_3_2_5 T2_5 SN3 10k
RXP_3_2_4 T2_4 SN3 10k
RXP_3_3_7 T3_7 SN3 10k
RXP_3_3_5 T3_5 SN3 10k
RXP_3_3_6 T3_6 SN3 10k
RXN_3_3_0 T3_0 SP3 10k
RXN_3_3_1 T3_1 SP3 10k
RXP_0_5_0 T5_0 SN0 10k
RXP_0_4_5 T4_5 SN0 10k
RXP_0_6_1 T6_1 SN0 10k
RXP_0_6_0 T6_0 SN0 10k
RXP_0_7_0 T7_0 SN0 10k
RXP_0_7_1 T7_1 SN0 10k
RXP_0_7_2 T7_2 SN0 10k
RXP_0_7_3 T7_3 SN0 10k
RXP_0_7_4 T7_4 SN0 10k
RXP_0_7_5 T7_5 SN0 10k
RXN_0_4_3 T4_3 SP0 10k
RXP_1_5_0 T5_0 SN1 10k
RXP_1_4_5 T4_5 SN1 10k
RXP_1_4_6 T4_6 SN1 10k
RXN_1_4_3 T4_3 SP1 10k
RXN_1_4_2 T4_2 SP1 10k
RXP_1_7_5 T7_5 SN1 10k
RXP_1_7_6 T7_6 SN1 10k
RXP_1_5_3 T5_3 SN1 10k
RXP_1_6_7 T6_7 SN1 10k
RXP_1_6_6 T6_6 SN1 10k
RXP_1_6_5 T6_5 SN1 10k
RXP_2_6_3 T6_3 SN2 10k
RXP_2_6_4 T6_4 SN2 10k
RXP_2_6_2 T6_2 SN2 10k
RXP_2_6_0 T6_0 SN2 10k
RXP_2_6_1 T6_1 SN2 10k
RXP_2_7_7 T7_7 SN2 10k
RXN_1_6_3 T6_3 SP1 10k
RXN_1_6_0 T6_0 SP1 10k
RXN_1_6_1 T6_1 SP1 10k
RXN_1_6_2 T6_2 SP1 10k
RXP_3_4_0 T4_0 SN3 10k
RXP_3_4_1 T4_1 SN3 10k
RXP_3_4_5 T4_5 SN3 10k
RXP_2_4_7 T4_7 SN2 10k
RXN_2_4_0 T4_0 SP2 10k
RXN_2_4_4 T4_4 SP2 10k
RXP_2_4_1 T4_1 SN2 10k
RXP_2_4_2 T4_2 SN2 10k
RXP_2_4_3 T4_3 SN2 10k
RXN_2_4_5 T4_5 SP2 10k
RXN_3_5_7 T5_7 SP3 10k
RXN_3_5_1 T5_1 SP3 10k
RXN_3_5_2 T5_2 SP3 10k
RXN_3_5_3 T5_3 SP3 10k
RXN_3_5_4 T5_4 SP3 10k
RXP_2_5_3 T5_3 SN2 10k
RXP_2_5_4 T5_4 SN2 10k
RXN_2_5_0 T5_0 SP2 10k
RXN_3_6_7 T6_7 SP3 10k
RXN_2_6_7 T6_7 SP2 10k
RXN_2_7_0 T7_0 SP2 10k
RXN_3_7_7 T7_7 SP3 10k
RXP_3_7_0 T7_0 SN3 10k
RXP_3_7_1 T7_1 SN3 10k
RXN_2_7_1 T7_1 SP2 10k
RXP_3_6_3 T6_3 SN3 10k
RXP_3_6_2 T6_2 SN3 10k
RXP_3_6_4 T6_4 SN3 10k
RXP_3_6_5 T6_5 SN3 10k
RXN_2_6_6 T6_6 SP2 10k
RXP_3_6_0 T6_0 SN3 10k
RXP_3_6_1 T6_1 SN3 10k
RXN_1_4_1 T4_1 SP1 10k
RXN_1_2_6 T2_6 SP1 10k
RXN_1_2_7 T2_7 SP1 10k
RXP_1_3_3 T3_3 SN1 10k
RXP_1_3_4 T3_4 SN1 10k
RXP_0_3_3 T3_3 SN0 10k
RXP_0_4_1 T4_1 SN0 10k
RXP_0_4_0 T4_0 SN0 10k
RXP_0_3_4 T3_4 SN0 10k
RXP_0_3_5 T3_5 SN0 10k
RXP_0_2_4 T2_4 SN0 10k
RXP_0_2_5 T2_5 SN0 10k
RXP_0_3_0 T3_0 SN0 10k
RXP_0_3_2 T3_2 SN0 10k
RXP_0_3_1 T3_1 SN0 10k
RXP_0_2_6 T2_6 SN0 10k
RXN_4_5_1 T5_1 SP4 10k
RXN_4_5_2 T5_2 SP4 10k
RXN_4_6_7 T6_7 SP4 10k
RXP_4_6_0 T6_0 SN4 10k
RXP_4_6_1 T6_1 SN4 10k
RXP_4_6_2 T6_2 SN4 10k
RXP_4_6_5 T6_5 SN4 10k
RXP_4_6_4 T6_4 SN4 10k
RXP_4_6_6 T6_6 SN4 10k
RXN_5_6_7 T6_7 SP5 10k
RXN_5_6_2 T6_2 SP5 10k
RXN_5_6_3 T6_3 SP5 10k
RXN_5_6_4 T6_4 SP5 10k
RXN_5_6_5 T6_5 SP5 10k
RXN_5_6_6 T6_6 SP5 10k
RXP_5_6_1 T6_1 SN5 10k
RXP_5_5_3 T5_3 SN5 10k
RXP_5_5_2 T5_2 SN5 10k
RXP_5_5_1 T5_1 SN5 10k
RXP_5_5_5 T5_5 SN5 10k
RXP_5_5_6 T5_6 SN5 10k
RXP_5_5_7 T5_7 SN5 10k
RXP_6_3_6 T3_6 SN6 10k
RXP_6_3_5 T3_5 SN6 10k
RXP_4_4_7 T4_7 SN4 10k
RXN_4_5_0 T5_0 SP4 10k
RXP_4_4_5 T4_5 SN4 10k
RXP_4_4_4 T4_4 SN4 10k
RXP_4_4_3 T4_3 SN4 10k
RXN_4_4_1 T4_1 SP4 10k
RXN_4_4_2 T4_2 SP4 10k
RXP_5_3_5 T3_5 SN5 10k
RXP_5_3_6 T3_6 SN5 10k
RXP_5_4_1 T4_1 SN5 10k
RXN_5_4_3 T4_3 SP5 10k
RXN_5_4_4 T4_4 SP5 10k
RXP_6_5_0 T5_0 SN6 10k
RXN_5_5_0 T5_0 SP5 10k
RXP_6_6_4 T6_4 SN6 10k
RXP_6_6_5 T6_5 SN6 10k
RXP_6_6_6 T6_6 SN6 10k
RXP_6_6_0 T6_0 SN6 10k
RXP_6_6_1 T6_1 SN6 10k
RXN_6_5_6 T5_6 SP6 10k
RXN_6_5_7 T5_7 SP6 10k
RXN_7_5_6 T5_6 SP7 10k
RXN_7_5_7 T5_7 SP7 10k
RXP_7_6_1 T6_1 SN7 10k
RXP_7_6_2 T6_2 SN7 10k
RXP_7_6_4 T6_4 SN7 10k
RXP_7_6_5 T6_5 SN7 10k
RXP_7_6_3 T6_3 SN7 10k
RXN_7_6_7 T6_7 SP7 10k
RXP_7_7_3 T7_3 SN7 10k
RXP_7_7_2 T7_2 SN7 10k
RXP_7_7_4 T7_4 SN7 10k
RXP_7_7_5 T7_5 SN7 10k
RXP_7_7_6 T7_6 SN7 10k
RXP_7_7_7 T7_7 SN7 10k
RXP_4_7_0 T7_0 SN4 10k
RXP_4_7_2 T7_2 SN4 10k
RXP_4_7_3 T7_3 SN4 10k
RXP_4_7_4 T7_4 SN4 10k
RXN_4_7_7 T7_7 SP4 10k
RXP_5_7_3 T7_3 SN5 10k
RXP_5_7_2 T7_2 SN5 10k
RXN_5_7_5 T7_5 SP5 10k
RXP_6_7_0 T7_0 SN6 10k
RXP_6_7_7 T7_7 SN6 10k
RXP_6_7_6 T7_6 SN6 10k
RXP_6_7_1 T7_1 SN6 10k
RXP_6_7_2 T7_2 SN6 10k
RXP_6_7_3 T7_3 SN6 10k
RXP_6_7_4 T7_4 SN6 10k
RXP_6_7_5 T7_5 SN6 10k
RXP_7_3_5 T3_5 SN7 10k
RXN_6_4_5 T4_5 SP6 10k
RXN_6_4_4 T4_4 SP6 10k
RXN_6_4_2 T4_2 SP6 10k
RXN_6_4_3 T4_3 SP6 10k
RXN_7_4_1 T4_1 SP7 10k
RXN_7_4_0 T4_0 SP7 10k
RXN_7_4_6 T4_6 SP7 10k
RXN_7_4_7 T4_7 SP7 10k
RXP_4_2_7 T2_7 SN4 10k
RXP_4_3_3 T3_3 SN4 10k
RXP_5_2_0 T2_0 SN5 10k
RXN_4_2_1 T2_1 SP4 10k
RXN_4_2_2 T2_2 SP4 10k
RXN_4_2_3 T2_3 SP4 10k
RXN_4_2_4 T2_4 SP4 10k
RXN_4_2_5 T2_5 SP4 10k
RXN_6_2_1 T2_1 SP6 10k
RXN_6_2_0 T2_0 SP6 10k
RXN_6_2_2 T2_2 SP6 10k
RXP_6_2_4 T2_4 SN6 10k
RXN_5_2_4 T2_4 SP5 10k
RXN_5_2_5 T2_5 SP5 10k
RXN_5_2_7 T2_7 SP5 10k
RXN_5_2_6 T2_6 SP5 10k
RXP_7_2_0 T2_0 SN7 10k
RXP_7_2_4 T2_4 SN7 10k
RXP_7_3_3 T3_3 SN7 10k
RXP_7_3_4 T3_4 SN7 10k
RXN_6_2_7 T2_7 SP6 10k
RXP_6_3_0 T3_0 SN6 10k
RXP_6_3_1 T3_1 SN6 10k
RXP_6_3_3 T3_3 SN6 10k
RXP_6_3_2 T3_2 SN6 10k
RXP_6_3_4 T3_4 SN6 10k
RXN_5_3_2 T3_2 SP5 10k
RXP_7_2_5 T2_5 SN7 10k
RXP_7_2_6 T2_6 SN7 10k
RXN_7_3_0 T3_0 SP7 10k
RXP_7_2_7 T2_7 SN7 10k
RXP_6_0_3 T0_3 SN6 10k
RXP_6_0_4 T0_4 SN6 10k
RXP_6_0_6 T0_6 SN6 10k
RXP_6_0_5 T0_5 SN6 10k
RXP_6_0_7 T0_7 SN6 10k
RXN_7_0_3 T0_3 SP7 10k
RXN_7_0_4 T0_4 SP7 10k
RXN_7_0_2 T0_2 SP7 10k
RXN_7_0_1 T0_1 SP7 10k
RXN_7_0_0 T0_0 SP7 10k
RXP_7_0_6 T0_6 SN7 10k
RXP_7_1_7 T1_7 SN7 10k
RXP_7_0_7 T0_7 SN7 10k
RXP_7_1_0 T1_0 SN7 10k
RXP_7_1_1 T1_1 SN7 10k
RXP_7_1_2 T1_2 SN7 10k
RXN_6_1_0 T1_0 SP6 10k
RXN_7_1_4 T1_4 SP7 10k
RXP_6_1_2 T1_2 SN6 10k
RXP_6_1_3 T1_3 SN6 10k
RXN_2_1_6 T1_6 SP2 10k
RXN_2_1_5 T1_5 SP2 10k
RXN_2_2_0 T2_0 SP2 10k
RXN_2_2_1 T2_1 SP2 10k
RXN_2_2_2 T2_2 SP2 10k
RXN_2_2_3 T2_3 SP2 10k
RXP_3_1_7 T1_7 SN3 10k
RXP_3_2_0 T2_0 SN3 10k
RXP_3_2_1 T2_1 SN3 10k
RXN_4_2_0 T2_0 SP4 10k
RXN_2_1_1 T1_1 SP2 10k
RXN_2_1_2 T1_2 SP2 10k
RXN_2_1_3 T1_3 SP2 10k
RXN_2_1_4 T1_4 SP2 10k
RXN_3_1_1 T1_1 SP3 10k
RXN_3_1_0 T1_0 SP3 10k
RXN_3_1_2 T1_2 SP3 10k
RXN_3_1_5 T1_5 SP3 10k
RXN_3_1_3 T1_3 SP3 10k
RXN_3_1_4 T1_4 SP3 10k
RXP_3_0_0 T0_0 SN3 10k
RXP_3_0_1 T0_1 SN3 10k
RXP_3_0_2 T0_2 SN3 10k
RXP_3_0_3 T0_3 SN3 10k
RXP_3_0_4 T0_4 SN3 10k
RXP_3_0_5 T0_5 SN3 10k
RXP_3_0_6 T0_6 SN3 10k
RXN_3_0_7 T0_7 SP3 10k
RXN_2_0_1 T0_1 SP2 10k
RXN_2_0_0 T0_0 SP2 10k
RXN_2_0_5 T0_5 SP2 10k
RXN_2_0_6 T0_6 SP2 10k
RXN_2_0_2 T0_2 SP2 10k
RXN_2_0_3 T0_3 SP2 10k
RXN_0_0_4 T0_4 SP0 10k
RXN_0_0_5 T0_5 SP0 10k
RXN_0_0_6 T0_6 SP0 10k
RXN_0_0_3 T0_3 SP0 10k
RXN_0_0_1 T0_1 SP0 10k
RXN_0_0_0 T0_0 SP0 10k
RXN_0_0_2 T0_2 SP0 10k
RXP_0_2_0 T2_0 SN0 10k
RXP_0_1_7 T1_7 SN0 10k
RXP_0_2_1 T2_1 SN0 10k
RXP_0_2_2 T2_2 SN0 10k
RXP_0_2_3 T2_3 SN0 10k
RXP_1_1_7 T1_7 SN1 10k
RXP_1_1_6 T1_6 SN1 10k
RXN_1_1_2 T1_2 SP1 10k
RXN_1_1_3 T1_3 SP1 10k
RXP_1_1_5 T1_5 SN1 10k
RXP_0_1_0 T1_0 SN0 10k
RXP_0_1_1 T1_1 SN0 10k
RXP_0_1_5 T1_5 SN0 10k
RXP_0_1_6 T1_6 SN0 10k
RXP_1_2_2 T2_2 SN1 10k
RXP_1_2_3 T2_3 SN1 10k
RXP_1_0_2 T0_2 SN1 10k
RXP_1_0_1 T0_1 SN1 10k
RXP_1_0_0 T0_0 SN1 10k
RXN_1_0_5 T0_5 SP1 10k
RXN_1_0_6 T0_6 SP1 10k
RXP_1_0_3 T0_3 SN1 10k
RXN_1_0_4 T0_4 SP1 10k
RXN_1_1_1 T1_1 SP1 10k
RXN_1_1_0 T1_0 SP1 10k
RXP_4_0_0 T0_0 SN4 10k
RXP_4_0_1 T0_1 SN4 10k
RXP_4_0_2 T0_2 SN4 10k
RXP_4_0_4 T0_4 SN4 10k
RXP_4_0_3 T0_3 SN4 10k
RXP_5_0_2 T0_2 SN5 10k
RXP_5_0_3 T0_3 SN5 10k
RXP_5_0_4 T0_4 SN5 10k
RXP_5_0_7 T0_7 SN5 10k
RXP_4_1_6 T1_6 SN4 10k
RXP_4_1_1 T1_1 SN4 10k
RXP_4_1_0 T1_0 SN4 10k
RXN_4_0_7 T0_7 SP4 10k
RXP_4_1_5 T1_5 SN4 10k
RXP_4_1_4 T1_4 SN4 10k
RXP_4_1_2 T1_2 SN4 10k
RXP_5_1_5 T1_5 SN5 10k
RXP_5_1_7 T1_7 SN5 10k
RXN_4_1_3 T1_3 SP4 10k
RXP_5_1_4 T1_4 SN5 10k
RXP_5_1_2 T1_2 SN5 10k
RXP_5_1_3 T1_3 SN5 10k
RFP0 SP0 /ch0/OP 365
CFP0 SP0 /ch0/OP 15p
XUCS0 VREF25 SP0 /ch0/OP +5VA VREF25 SN0 /ch0/ON VREF25 SP1 /ch1/OP VREF25 SN1 /ch1/ON GND OPA_QUAD
RFN0 SN0 /ch0/ON 365
CFN0 SN0 /ch0/ON 15p
RB0 BIAS0 SN0 3.16k
CBF0 BIAS0 GND 100n
RO0 +5VA SN0 5.36k
RLD1_0 +5VA /ch0/DC1 1k
XQD0 /ch0/TAIL /ch0/ON /ch0/DC2 /ch0/TAIL /ch0/OP /ch0/DC1 DUAL_NPN
XUT0 GND MIRB /ch1/TAIL GND MIRB /ch0/TAIL DUAL_NPN
RDA4_0 /ch0/DAIN /ch0/DAO 10.5k
CDA0 /ch0/DAIN /ch0/DAO 8.2p
RLD2_0 +5VA /ch0/DC2 1k
RDA1_0 /ch0/DC1 /ch0/DAIP 20k
RDA2_0 /ch0/DAIP VREF25 10.5k
XUDA0 /ch0/DAIP /ch0/DAIN /ch0/DAO +5VA /ch0/HOLD OUT0 OUT0 /ch1/DAIP /ch1/DAIN /ch1/DAO /ch1/HOLD OUT1 OUT1 GND OPA_QUAD
RDA3_0 /ch0/DC2 /ch0/DAIN 20k
XUSH0 /ch0/DAO /ch0/HOLD SH_CLK /ch1/DAO /ch1/HOLD SH_CLK /ch2/DAO /ch2/HOLD SH_CLK /ch3/DAO /ch3/HOLD SH_CLK +5VA GND SW4066_QUAD
CDSH0 +5VA GND 100n
CH0 /ch0/HOLD GND 560p
CDCS0 +5VA GND 100n
CDDA0 +5VA GND 100n
RFP1 SP1 /ch1/OP 365
CFP1 SP1 /ch1/OP 15p
CH1 /ch1/HOLD GND 560p
RFN1 SN1 /ch1/ON 365
CFN1 SN1 /ch1/ON 15p
RB1 BIAS1 SN1 3.16k
CBF1 BIAS1 GND 100n
RO1 +5VA SN1 5.36k
RLD1_1 +5VA /ch1/DC1 1k
XQD1 /ch1/TAIL /ch1/ON /ch1/DC2 /ch1/TAIL /ch1/OP /ch1/DC1 DUAL_NPN
RDA4_1 /ch1/DAIN /ch1/DAO 10.5k
CDA1 /ch1/DAIN /ch1/DAO 8.2p
RLD2_1 +5VA /ch1/DC2 1k
RDA1_1 /ch1/DC1 /ch1/DAIP 20k
RDA2_1 /ch1/DAIP VREF25 10.5k
RDA3_1 /ch1/DC2 /ch1/DAIN 20k
RFP2 SP2 /ch2/OP 365
CFP2 SP2 /ch2/OP 15p
XUCS1 VREF25 SP2 /ch2/OP +5VA VREF25 SN2 /ch2/ON VREF25 SP3 /ch3/OP VREF25 SN3 /ch3/ON GND OPA_QUAD
RFN2 SN2 /ch2/ON 365
CFN2 SN2 /ch2/ON 15p
RB2 BIAS2 SN2 3.16k
CBF2 BIAS2 GND 100n
RO2 +5VA SN2 5.36k
RLD1_2 +5VA /ch2/DC1 1k
XQD2 /ch2/TAIL /ch2/ON /ch2/DC2 /ch2/TAIL /ch2/OP /ch2/DC1 DUAL_NPN
XUT1 GND MIRB /ch3/TAIL GND MIRB /ch2/TAIL DUAL_NPN
RDA4_2 /ch2/DAIN /ch2/DAO 10.5k
CDA2 /ch2/DAIN /ch2/DAO 8.2p
RLD2_2 +5VA /ch2/DC2 1k
RDA1_2 /ch2/DC1 /ch2/DAIP 20k
RDA2_2 /ch2/DAIP VREF25 10.5k
XUDA1 /ch2/DAIP /ch2/DAIN /ch2/DAO +5VA /ch2/HOLD OUT2 OUT2 /ch3/DAIP /ch3/DAIN /ch3/DAO /ch3/HOLD OUT3 OUT3 GND OPA_QUAD
RDA3_2 /ch2/DC2 /ch2/DAIN 20k
CDDA1 +5VA GND 100n
CH2 /ch2/HOLD GND 560p
CDCS1 +5VA GND 100n
RFP3 SP3 /ch3/OP 365
CFP3 SP3 /ch3/OP 15p
CH3 /ch3/HOLD GND 560p
RFN3 SN3 /ch3/ON 365
CFN3 SN3 /ch3/ON 15p
RB3 BIAS3 SN3 3.16k
CBF3 BIAS3 GND 100n
RO3 +5VA SN3 5.36k
RLD1_3 +5VA /ch3/DC1 1k
XQD3 /ch3/TAIL /ch3/ON /ch3/DC2 /ch3/TAIL /ch3/OP /ch3/DC1 DUAL_NPN
RDA4_3 /ch3/DAIN /ch3/DAO 10.5k
CDA3 /ch3/DAIN /ch3/DAO 8.2p
RLD2_3 +5VA /ch3/DC2 1k
RDA1_3 /ch3/DC1 /ch3/DAIP 20k
RDA2_3 /ch3/DAIP VREF25 10.5k
RDA3_3 /ch3/DC2 /ch3/DAIN 20k
RFP4 SP4 /ch4/OP 365
CFP4 SP4 /ch4/OP 15p
XUCS2 VREF25 SP4 /ch4/OP +5VA VREF25 SN4 /ch4/ON VREF25 SP5 /ch5/OP VREF25 SN5 /ch5/ON GND OPA_QUAD
RFN4 SN4 /ch4/ON 365
CFN4 SN4 /ch4/ON 15p
RB4 BIAS4 SN4 3.16k
CBF4 BIAS4 GND 100n
RO4 +5VA SN4 5.36k
RLD1_4 +5VA /ch4/DC1 1k
XQD4 /ch4/TAIL /ch4/ON /ch4/DC2 /ch4/TAIL /ch4/OP /ch4/DC1 DUAL_NPN
XUT2 GND MIRB /ch5/TAIL GND MIRB /ch4/TAIL DUAL_NPN
RDA4_4 /ch4/DAIN /ch4/DAO 10.5k
CDA4 /ch4/DAIN /ch4/DAO 8.2p
RLD2_4 +5VA /ch4/DC2 1k
RDA1_4 /ch4/DC1 /ch4/DAIP 20k
RDA2_4 /ch4/DAIP VREF25 10.5k
XUDA2 /ch4/DAIP /ch4/DAIN /ch4/DAO +5VA /ch4/HOLD OUT4 OUT4 /ch5/DAIP /ch5/DAIN /ch5/DAO /ch5/HOLD OUT5 OUT5 GND OPA_QUAD
RDA3_4 /ch4/DC2 /ch4/DAIN 20k
XUSH1 /ch4/DAO /ch4/HOLD SH_CLK /ch5/DAO /ch5/HOLD SH_CLK /ch6/DAO /ch6/HOLD SH_CLK /ch7/DAO /ch7/HOLD SH_CLK +5VA GND SW4066_QUAD
CDSH1 +5VA GND 100n
CH4 /ch4/HOLD GND 560p
CDCS2 +5VA GND 100n
CDDA2 +5VA GND 100n
RFP5 SP5 /ch5/OP 365
CFP5 SP5 /ch5/OP 15p
CH5 /ch5/HOLD GND 560p
RFN5 SN5 /ch5/ON 365
CFN5 SN5 /ch5/ON 15p
RB5 BIAS5 SN5 3.16k
CBF5 BIAS5 GND 100n
RO5 +5VA SN5 5.36k
RLD1_5 +5VA /ch5/DC1 1k
XQD5 /ch5/TAIL /ch5/ON /ch5/DC2 /ch5/TAIL /ch5/OP /ch5/DC1 DUAL_NPN
RDA4_5 /ch5/DAIN /ch5/DAO 10.5k
CDA5 /ch5/DAIN /ch5/DAO 8.2p
RLD2_5 +5VA /ch5/DC2 1k
RDA1_5 /ch5/DC1 /ch5/DAIP 20k
RDA2_5 /ch5/DAIP VREF25 10.5k
RDA3_5 /ch5/DC2 /ch5/DAIN 20k
RFP6 SP6 /ch6/OP 365
CFP6 SP6 /ch6/OP 15p
XUCS3 VREF25 SP6 /ch6/OP +5VA VREF25 SN6 /ch6/ON VREF25 SP7 /ch7/OP VREF25 SN7 /ch7/ON GND OPA_QUAD
RFN6 SN6 /ch6/ON 365
CFN6 SN6 /ch6/ON 15p
RB6 BIAS6 SN6 3.16k
CBF6 BIAS6 GND 100n
RO6 +5VA SN6 5.36k
RLD1_6 +5VA /ch6/DC1 1k
XQD6 /ch6/TAIL /ch6/ON /ch6/DC2 /ch6/TAIL /ch6/OP /ch6/DC1 DUAL_NPN
XUT3 GND MIRB /ch7/TAIL GND MIRB /ch6/TAIL DUAL_NPN
RDA4_6 /ch6/DAIN /ch6/DAO 10.5k
CDA6 /ch6/DAIN /ch6/DAO 8.2p
RLD2_6 +5VA /ch6/DC2 1k
RDA1_6 /ch6/DC1 /ch6/DAIP 20k
RDA2_6 /ch6/DAIP VREF25 10.5k
XUDA3 /ch6/DAIP /ch6/DAIN /ch6/DAO +5VA /ch6/HOLD OUT6 OUT6 /ch7/DAIP /ch7/DAIN /ch7/DAO /ch7/HOLD OUT7 OUT7 GND OPA_QUAD
RDA3_6 /ch6/DC2 /ch6/DAIN 20k
CDDA3 +5VA GND 100n
CH6 /ch6/HOLD GND 560p
CDCS3 +5VA GND 100n
RFP7 SP7 /ch7/OP 365
CFP7 SP7 /ch7/OP 15p
CH7 /ch7/HOLD GND 560p
RFN7 SN7 /ch7/ON 365
CFN7 SN7 /ch7/ON 15p
RB7 BIAS7 SN7 3.16k
CBF7 BIAS7 GND 100n
RO7 +5VA SN7 5.36k
RLD1_7 +5VA /ch7/DC1 1k
XQD7 /ch7/TAIL /ch7/ON /ch7/DC2 /ch7/TAIL /ch7/OP /ch7/DC1 DUAL_NPN
RDA4_7 /ch7/DAIN /ch7/DAO 10.5k
CDA7 /ch7/DAIN /ch7/DAO 8.2p
RLD2_7 +5VA /ch7/DC2 1k
RDA1_7 /ch7/DC1 /ch7/DAIP 20k
RDA2_7 /ch7/DAIP VREF25 10.5k
RDA3_7 /ch7/DC2 /ch7/DAIN 20k
RID2 +3V3 /connectors/TID2 10k
RID0 +3V3 /connectors/TID0 10k
RID1 +3V3 /connectors/TID1 10k
CDDAC1 +3V3 GND 100n
XUDAC1 +3V3 /connectors/SCL1 /connectors/SDA1 GND unconnected-_UDAC1-RDY/_BSY-Pad5_ BIAS4 BIAS5 BIAS6 BIAS7 GND DAC4_IDEAL
XUDAC0 +3V3 /connectors/SCL0 /connectors/SDA0 GND unconnected-_UDAC0-RDY/_BSY-Pad5_ BIAS0 BIAS1 BIAS2 BIAS3 GND DAC4_IDEAL
CDDAC0 +3V3 GND 100n
CDMUX1 +3V3 GND 100n
RPU3 +3V3 /connectors/SDA1 10k
RPU4 +3V3 /connectors/SCL1 10k
RPU1 +3V3 /connectors/SDA0 10k
RPU2 +3V3 /connectors/SCL0 10k
.end
