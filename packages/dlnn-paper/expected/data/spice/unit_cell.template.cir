* TILE-8 unit cell for the browser (ngspice-wasm): ONE delay line (56 LC sections) + 8 taps + one inverting summer + BJT diff pair.
* SIMULATION of a design that is not built.  Reduced model, no proprietary TI macro: the op-amps are SINGLE-POLE op-amps
* (A0 = 1e5, GBW = 10 MHz, labelled fit, not the TLV9062 macro); inductor = L + DCR + Cp(SRF) + Rp(Q) (datasheet-derived lumped);
* NPN = generic BC847-fitted.  Placeholders {{...}} are filled by the widget: {{Q_RP}} Rp for the chosen Q (Q=10: 6350.9, Q=30: 21561.8),
* {{RXP0}}..{{RXP7}} / {{RXN0}}..{{RXN7}} = 10k if the tap weight is +1 / -1 on that side, else 1G (footprint not populated), {{VIN_PWL}} PWL of the input voltage about 2.5 V.
.param RP={{Q_RP}} DCR=3.3 CP=19.383p
.model QNPN npn (IS=1.3520e-14 BF=300 VAF=100 RB=10 TF=0.6n CJE=13p CJC=4.8p MJE=0.33 MJC=0.33 VJE=0.75 VJC=0.75)
.subckt OPA inp inn out
E1 x 0 inp inn 1e5
R1 x y 1k
C1 y 0 1.5915e-06
Eo z 0 y 0 1
Ro z out 100
.ends OPA
Vdd vdd 0 5
Vref ref 0 2.5
Vin vin 0 PWL({{VIN_PWL}})
Rp0 vin rc 1k
Cp0 rc 0 330p
Xib rc ib ib OPA
Rs ib n0 1k
C00 n0 0 60p
Rd1 n0 m1 {DCR}
L1 m1 n1 120u
Cpp1 n0 n1 {CP}
Rpp1 n0 n1 {RP}
C1 n1 0 120p
Rd2 n1 m2 {DCR}
L2 m2 n2 120u
Cpp2 n1 n2 {CP}
Rpp2 n1 n2 {RP}
C2 n2 0 120p
Rd3 n2 m3 {DCR}
L3 m3 n3 120u
Cpp3 n2 n3 {CP}
Rpp3 n2 n3 {RP}
C3 n3 0 120p
Rd4 n3 m4 {DCR}
L4 m4 n4 120u
Cpp4 n3 n4 {CP}
Rpp4 n3 n4 {RP}
C4 n4 0 120p
Rd5 n4 m5 {DCR}
L5 m5 n5 120u
Cpp5 n4 n5 {CP}
Rpp5 n4 n5 {RP}
C5 n5 0 120p
Rd6 n5 m6 {DCR}
L6 m6 n6 120u
Cpp6 n5 n6 {CP}
Rpp6 n5 n6 {RP}
C6 n6 0 120p
Rd7 n6 m7 {DCR}
L7 m7 n7 120u
Cpp7 n6 n7 {CP}
Rpp7 n6 n7 {RP}
C7 n7 0 120p
Rd8 n7 m8 {DCR}
L8 m8 n8 120u
Cpp8 n7 n8 {CP}
Rpp8 n7 n8 {RP}
C8 n8 0 120p
Rd9 n8 m9 {DCR}
L9 m9 n9 120u
Cpp9 n8 n9 {CP}
Rpp9 n8 n9 {RP}
C9 n9 0 120p
Rd10 n9 m10 {DCR}
L10 m10 n10 120u
Cpp10 n9 n10 {CP}
Rpp10 n9 n10 {RP}
C10 n10 0 120p
Rd11 n10 m11 {DCR}
L11 m11 n11 120u
Cpp11 n10 n11 {CP}
Rpp11 n10 n11 {RP}
C11 n11 0 120p
Rd12 n11 m12 {DCR}
L12 m12 n12 120u
Cpp12 n11 n12 {CP}
Rpp12 n11 n12 {RP}
C12 n12 0 120p
Rd13 n12 m13 {DCR}
L13 m13 n13 120u
Cpp13 n12 n13 {CP}
Rpp13 n12 n13 {RP}
C13 n13 0 120p
Rd14 n13 m14 {DCR}
L14 m14 n14 120u
Cpp14 n13 n14 {CP}
Rpp14 n13 n14 {RP}
C14 n14 0 120p
Rd15 n14 m15 {DCR}
L15 m15 n15 120u
Cpp15 n14 n15 {CP}
Rpp15 n14 n15 {RP}
C15 n15 0 120p
Rd16 n15 m16 {DCR}
L16 m16 n16 120u
Cpp16 n15 n16 {CP}
Rpp16 n15 n16 {RP}
C16 n16 0 120p
Rd17 n16 m17 {DCR}
L17 m17 n17 120u
Cpp17 n16 n17 {CP}
Rpp17 n16 n17 {RP}
C17 n17 0 120p
Rd18 n17 m18 {DCR}
L18 m18 n18 120u
Cpp18 n17 n18 {CP}
Rpp18 n17 n18 {RP}
C18 n18 0 120p
Rd19 n18 m19 {DCR}
L19 m19 n19 120u
Cpp19 n18 n19 {CP}
Rpp19 n18 n19 {RP}
C19 n19 0 120p
Rd20 n19 m20 {DCR}
L20 m20 n20 120u
Cpp20 n19 n20 {CP}
Rpp20 n19 n20 {RP}
C20 n20 0 120p
Rd21 n20 m21 {DCR}
L21 m21 n21 120u
Cpp21 n20 n21 {CP}
Rpp21 n20 n21 {RP}
C21 n21 0 120p
Rd22 n21 m22 {DCR}
L22 m22 n22 120u
Cpp22 n21 n22 {CP}
Rpp22 n21 n22 {RP}
C22 n22 0 120p
Rd23 n22 m23 {DCR}
L23 m23 n23 120u
Cpp23 n22 n23 {CP}
Rpp23 n22 n23 {RP}
C23 n23 0 120p
Rd24 n23 m24 {DCR}
L24 m24 n24 120u
Cpp24 n23 n24 {CP}
Rpp24 n23 n24 {RP}
C24 n24 0 120p
Rd25 n24 m25 {DCR}
L25 m25 n25 120u
Cpp25 n24 n25 {CP}
Rpp25 n24 n25 {RP}
C25 n25 0 120p
Rd26 n25 m26 {DCR}
L26 m26 n26 120u
Cpp26 n25 n26 {CP}
Rpp26 n25 n26 {RP}
C26 n26 0 120p
Rd27 n26 m27 {DCR}
L27 m27 n27 120u
Cpp27 n26 n27 {CP}
Rpp27 n26 n27 {RP}
C27 n27 0 120p
Rd28 n27 m28 {DCR}
L28 m28 n28 120u
Cpp28 n27 n28 {CP}
Rpp28 n27 n28 {RP}
C28 n28 0 120p
Rd29 n28 m29 {DCR}
L29 m29 n29 120u
Cpp29 n28 n29 {CP}
Rpp29 n28 n29 {RP}
C29 n29 0 120p
Rd30 n29 m30 {DCR}
L30 m30 n30 120u
Cpp30 n29 n30 {CP}
Rpp30 n29 n30 {RP}
C30 n30 0 120p
Rd31 n30 m31 {DCR}
L31 m31 n31 120u
Cpp31 n30 n31 {CP}
Rpp31 n30 n31 {RP}
C31 n31 0 120p
Rd32 n31 m32 {DCR}
L32 m32 n32 120u
Cpp32 n31 n32 {CP}
Rpp32 n31 n32 {RP}
C32 n32 0 120p
Rd33 n32 m33 {DCR}
L33 m33 n33 120u
Cpp33 n32 n33 {CP}
Rpp33 n32 n33 {RP}
C33 n33 0 120p
Rd34 n33 m34 {DCR}
L34 m34 n34 120u
Cpp34 n33 n34 {CP}
Rpp34 n33 n34 {RP}
C34 n34 0 120p
Rd35 n34 m35 {DCR}
L35 m35 n35 120u
Cpp35 n34 n35 {CP}
Rpp35 n34 n35 {RP}
C35 n35 0 120p
Rd36 n35 m36 {DCR}
L36 m36 n36 120u
Cpp36 n35 n36 {CP}
Rpp36 n35 n36 {RP}
C36 n36 0 120p
Rd37 n36 m37 {DCR}
L37 m37 n37 120u
Cpp37 n36 n37 {CP}
Rpp37 n36 n37 {RP}
C37 n37 0 120p
Rd38 n37 m38 {DCR}
L38 m38 n38 120u
Cpp38 n37 n38 {CP}
Rpp38 n37 n38 {RP}
C38 n38 0 120p
Rd39 n38 m39 {DCR}
L39 m39 n39 120u
Cpp39 n38 n39 {CP}
Rpp39 n38 n39 {RP}
C39 n39 0 120p
Rd40 n39 m40 {DCR}
L40 m40 n40 120u
Cpp40 n39 n40 {CP}
Rpp40 n39 n40 {RP}
C40 n40 0 120p
Rd41 n40 m41 {DCR}
L41 m41 n41 120u
Cpp41 n40 n41 {CP}
Rpp41 n40 n41 {RP}
C41 n41 0 120p
Rd42 n41 m42 {DCR}
L42 m42 n42 120u
Cpp42 n41 n42 {CP}
Rpp42 n41 n42 {RP}
C42 n42 0 120p
Rd43 n42 m43 {DCR}
L43 m43 n43 120u
Cpp43 n42 n43 {CP}
Rpp43 n42 n43 {RP}
C43 n43 0 120p
Rd44 n43 m44 {DCR}
L44 m44 n44 120u
Cpp44 n43 n44 {CP}
Rpp44 n43 n44 {RP}
C44 n44 0 120p
Rd45 n44 m45 {DCR}
L45 m45 n45 120u
Cpp45 n44 n45 {CP}
Rpp45 n44 n45 {RP}
C45 n45 0 120p
Rd46 n45 m46 {DCR}
L46 m46 n46 120u
Cpp46 n45 n46 {CP}
Rpp46 n45 n46 {RP}
C46 n46 0 120p
Rd47 n46 m47 {DCR}
L47 m47 n47 120u
Cpp47 n46 n47 {CP}
Rpp47 n46 n47 {RP}
C47 n47 0 120p
Rd48 n47 m48 {DCR}
L48 m48 n48 120u
Cpp48 n47 n48 {CP}
Rpp48 n47 n48 {RP}
C48 n48 0 120p
Rd49 n48 m49 {DCR}
L49 m49 n49 120u
Cpp49 n48 n49 {CP}
Rpp49 n48 n49 {RP}
C49 n49 0 120p
Rd50 n49 m50 {DCR}
L50 m50 n50 120u
Cpp50 n49 n50 {CP}
Rpp50 n49 n50 {RP}
C50 n50 0 120p
Rd51 n50 m51 {DCR}
L51 m51 n51 120u
Cpp51 n50 n51 {CP}
Rpp51 n50 n51 {RP}
C51 n51 0 120p
Rd52 n51 m52 {DCR}
L52 m52 n52 120u
Cpp52 n51 n52 {CP}
Rpp52 n51 n52 {RP}
C52 n52 0 120p
Rd53 n52 m53 {DCR}
L53 m53 n53 120u
Cpp53 n52 n53 {CP}
Rpp53 n52 n53 {RP}
C53 n53 0 120p
Rd54 n53 m54 {DCR}
L54 m54 n54 120u
Cpp54 n53 n54 {CP}
Rpp54 n53 n54 {RP}
C54 n54 0 120p
Rd55 n54 m55 {DCR}
L55 m55 n55 120u
Cpp55 n54 n55 {CP}
Rpp55 n54 n55 {RP}
C55 n55 0 120p
Rd56 n55 m56 {DCR}
L56 m56 n56 120u
Cpp56 n55 n56 {CP}
Rpp56 n55 n56 {RP}
C56 n56 0 60p
Rt n56 ref 1k
Xt0 n0 t0 t0 OPA
Xt1 n8 t1 t1 OPA
Xt2 n16 t2 t2 OPA
Xt3 n24 t3 t3 OPA
Xt4 n32 t4 t4 OPA
Xt5 n40 t5 t5 OPA
Xt6 n48 t6 t6 OPA
Xt7 n56 t7 t7 OPA
* crossbar: W=+1 populates Rxp (to sn), W=-1 populates Rxn (to sp), as on the board
Rxp0 t0 sn {{RXP0}}
Rxn0 t0 sp {{RXN0}}
Rxp1 t1 sn {{RXP1}}
Rxn1 t1 sp {{RXN1}}
Rxp2 t2 sn {{RXP2}}
Rxn2 t2 sp {{RXN2}}
Rxp3 t3 sn {{RXP3}}
Rxn3 t3 sp {{RXN3}}
Rxp4 t4 sn {{RXP4}}
Rxn4 t4 sp {{RXN4}}
Rxp5 t5 sn {{RXP5}}
Rxn5 t5 sp {{RXN5}}
Rxp6 t6 sn {{RXP6}}
Rxn6 t6 sp {{RXN6}}
Rxp7 t7 sn {{RXP7}}
Rxn7 t7 sp {{RXN7}}
Xs1 ref sn on OPA
Rfn sn on 1058
Cfn sn on 15p
Xs2 ref sp op OPA
Rfp sp op 1058
Cfp sp op 15p
* generic BJT pair, mirror-less 1 mA ideal tail (the board uses a BJT mirror; see tap/dc exports for the full tile)
Q1 c1 on tail QNPN
Q2 c2 op tail QNPN
Itail tail 0 1m
Rl1 vdd c1 1k
Rl2 vdd c2 1k
Eout out 0 c2 c1 1
.end
